* Latencia do caminho critico com LT1810: cadeia de 5 somadores inversores
* unitarios (Rf = Ri = 100k, mesmos ganhos de pior caso da rede) seguida do
* comparador contra VTH. A rede completa com o modelo de 325 MHz do LT1810
* exigiria passos de sub-nanosegundo por horas; o caminho critico de cinco
* estagios da a mesma latencia de decisao com 6 AmpOps. O degrau entra em
* t=30us, depois da rampa de 20us do startup terminar.
* Compensacao: com 100k de realimentacao, a capacitancia de entrada do
* LT1810 cria um polo dentro da banda de 325 MHz e cada estagio oscila;
* 2 pF em paralelo com cada Rf fecham a malha abaixo do polo e definem a
* banda de cada estagio (~800 kHz). A latencia passa a ser limitada pelo
* RC da compensacao, nao pelo slew rate.
* Equilibrio de polarizacao: a corrente de polarizacao de ~1.5 uA do
* LT1810 (bipolar) sobre 100k desloca cada estagio ~0.15 V; o resistor
* de 49.9k (= Ri || Rf) na entrada nao inversora cancela o efeito.
.lib LTC.lib
VCC vcc 0 4.8
VEE vee 0 -4.8
VEER veer 0 0
VTH vth 0 2.65
VIN in 0 PWL(0 3 30u 3 30.01u -3 50u -3)
R1 in s1 100k
RF1 a1 s1 100k
CF1 a1 s1 2p
X1 b1 s1 vcc vee a1 LT1810
RB1 b1 0 49.9k
R2 a1 s2 100k
RF2 a2 s2 100k
CF2 a2 s2 2p
X2 b2 s2 vcc vee a2 LT1810
RB2 b2 0 49.9k
R3 a2 s3 100k
RF3 a3 s3 100k
CF3 a3 s3 2p
X3 b3 s3 vcc vee a3 LT1810
RB3 b3 0 49.9k
R4 a3 s4 100k
RF4 a4 s4 100k
CF4 a4 s4 2p
X4 b4 s4 vcc vee a4 LT1810
RB4 b4 0 49.9k
R5 a4 s5 100k
RF5 z s5 100k
CF5 z s5 2p
X5 b5 s5 vcc vee z LT1810
RB5 b5 0 49.9k
XC z vth vcc veer outc LT1810
RL outc 0 100k
.options method=Gear
.tran 0 50u 0 2n startup
.meas TRAN t_dec WHEN V(outc)=2.4 RISE=1
.meas TRAN lat_us PARAM (t_dec-30.01u)/1e-6
.end
