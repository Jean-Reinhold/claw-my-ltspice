* Calibracao de saturacao do LT1810 para a rede analog-mlp
* Mesmo procedimento do bench_741_sat.cir: somador inversor (Rf = Ri = 100k)
* levado alem dos trilhos; a varredura DC registra onde a saida satura de
* verdade para cada par de alimentacoes. Como o LT1810 e rail-to-rail,
* espera-se folga de poucas dezenas de milivolts.
.lib LTC.lib
.param vcp=4.85 vem=-0.05
VCC vcc 0 {vcp}
VEE vee 0 {vem}
VIN vin 0 0
RIN vin sum 100k
RF out sum 100k
X1 0 sum vcc vee out LT1810
RL out 0 100k
.dc VIN -7 7 0.02
.meas DC vhigh MAX V(out)
.meas DC vlow MIN V(out)
.step param vcp list 4.82 4.85 4.9 5
.step param vem list -0.02 -0.05 -0.1 -0.2
.end
