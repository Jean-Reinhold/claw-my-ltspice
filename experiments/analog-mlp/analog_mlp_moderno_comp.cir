* Analog MLP - 5-stage op-amp MNIST classifier (LT1810 variant)
* Generated by analog_mlp.py from analog_mlp_weights.json - do not edit by hand.
.lib LTC.lib
VCC vcc 0 4.8
VEE vee 0 -4.8
VEER veer 0 0
VBP bp 0 1
VBN bn 0 -1
VTH vth 0 2.65
VX0 x0 0 0
BNX0 nx0 0 V=-V(x0)
VX1 x1 0 PWL(0 0 15u 0 15.3u 0 30u 0 30.3u 0 45u 0 45.3u 0.0231 60u 0.0231 60.3u 0 75u 0 75.3u 0)
BNX1 nx1 0 V=-V(x1)
VX2 x2 0 PWL(0 0 15u 0 15.3u 0 30u 0 30.3u 0.2344 45u 0.2344 45.3u 0.1481 60u 0.1481 60.3u 0 75u 0 75.3u 0)
BNX2 nx2 0 V=-V(x2)
VX3 x3 0 PWL(0 0.0702 15u 0.0702 15.3u 0 30u 0 30.3u 0.5708 45u 0.5708 45.3u 0 60u 0 60.3u 0 75u 0 75.3u 0)
BNX3 nx3 0 V=-V(x3)
VX4 x4 0 PWL(0 0.2118 15u 0.2118 15.3u 0.0166 30u 0.0166 30.3u 0.5325 45u 0.5325 45.3u 0 60u 0 60.3u 0 75u 0 75.3u 0)
BNX4 nx4 0 V=-V(x4)
VX5 x5 0 PWL(0 0 15u 0 15.3u 0.1582 30u 0.1582 30.3u 0.0131 45u 0.0131 45.3u 0 60u 0 60.3u 0 75u 0 75.3u 0.0484)
BNX5 nx5 0 V=-V(x5)
VX6 x6 0 PWL(0 0 15u 0 15.3u 0 30u 0 30.3u 0 45u 0 45.3u 0 60u 0 60.3u 0 75u 0 75.3u 0.0837)
BNX6 nx6 0 V=-V(x6)
VX7 x7 0 PWL(0 0 15u 0 15.3u 0 30u 0 30.3u 0 45u 0 45.3u 0 60u 0 60.3u 0 75u 0 75.3u 0.0575)
BNX7 nx7 0 V=-V(x7)
VX8 x8 0 0
BNX8 nx8 0 V=-V(x8)
VX9 x9 0 PWL(0 0 15u 0 15.3u 0 30u 0 30.3u 0.0562 45u 0.0562 45.3u 0.7142 60u 0.7142 60.3u 0 75u 0 75.3u 0)
BNX9 nx9 0 V=-V(x9)
VX10 x10 0 PWL(0 0.0479 15u 0.0479 15.3u 0 30u 0 30.3u 0.8166 45u 0.8166 45.3u 0.8144 60u 0.8144 60.3u 0.1612 75u 0.1612 75.3u 0)
BNX10 nx10 0 V=-V(x10)
VX11 x11 0 PWL(0 0.6314 15u 0.6314 15.3u 0 30u 0 30.3u 0.2841 45u 0.2841 45.3u 0.6405 60u 0.6405 60.3u 0.2989 75u 0.2989 75.3u 0.2148)
BNX11 nx11 0 V=-V(x11)
VX12 x12 0 PWL(0 0.8257 15u 0.8257 15.3u 0.2227 30u 0.2227 30.3u 0.7712 45u 0.7712 45.3u 0.0601 60u 0.0601 60.3u 0 75u 0 75.3u 0.7564)
BNX12 nx12 0 V=-V(x12)
VX13 x13 0 PWL(0 0.0745 15u 0.0745 15.3u 0.3159 30u 0.3159 30.3u 0.1425 45u 0.1425 45.3u 0 60u 0 60.3u 0.1368 75u 0.1368 75.3u 0.9765)
BNX13 nx13 0 V=-V(x13)
VX14 x14 0 PWL(0 0 15u 0 15.3u 0 30u 0 30.3u 0 45u 0 45.3u 0 60u 0 60.3u 0.1821 75u 0.1821 75.3u 0.8828)
BNX14 nx14 0 V=-V(x14)
VX15 x15 0 PWL(0 0 15u 0 15.3u 0 30u 0 30.3u 0 45u 0 45.3u 0 60u 0 60.3u 0 75u 0 75.3u 0.5891)
BNX15 nx15 0 V=-V(x15)
VX16 x16 0 0
BNX16 nx16 0 V=-V(x16)
VX17 x17 0 PWL(0 0 15u 0 15.3u 0 30u 0 30.3u 0 45u 0 45.3u 0.7076 60u 0.7076 60.3u 0 75u 0 75.3u 0.0845)
BNX17 nx17 0 V=-V(x17)
VX18 x18 0 PWL(0 0.5346 15u 0.5346 15.3u 0 30u 0 30.3u 0.0214 45u 0.0214 45.3u 0 60u 0 60.3u 0.5608 75u 0.5608 75.3u 0.5037)
BNX18 nx18 0 V=-V(x18)
VX19 x19 0 PWL(0 0.9869 15u 0.9869 15.3u 0 30u 0 30.3u 0.1917 45u 0.1917 45.3u 0.3725 60u 0.3725 60.3u 0.0636 75u 0.0636 75.3u 0.1425)
BNX19 nx19 0 V=-V(x19)
VX20 x20 0 PWL(0 0.7625 15u 0.7625 15.3u 0.5512 30u 0.5512 30.3u 0.854 45u 0.854 45.3u 0.7987 60u 0.7987 60.3u 0 75u 0 75.3u 0.2898)
BNX20 nx20 0 V=-V(x20)
VX21 x21 0 PWL(0 0.8327 15u 0.8327 15.3u 0.0322 30u 0.0322 30.3u 0.0327 45u 0.0327 45.3u 0.0392 60u 0.0392 60.3u 0.2523 75u 0.2523 75.3u 0.0928)
BNX21 nx21 0 V=-V(x21)
VX22 x22 0 PWL(0 0.0458 15u 0.0458 15.3u 0 30u 0 30.3u 0 45u 0 45.3u 0 60u 0 60.3u 0.3573 75u 0.3573 75.3u 0.0048)
BNX22 nx22 0 V=-V(x22)
VX23 x23 0 0
BNX23 nx23 0 V=-V(x23)
VX24 x24 0 0
BNX24 nx24 0 V=-V(x24)
VX25 x25 0 PWL(0 0.0462 15u 0.0462 15.3u 0 30u 0 30.3u 0 45u 0 45.3u 0.4244 60u 0.4244 60.3u 0.2148 75u 0.2148 75.3u 0.6723)
BNX25 nx25 0 V=-V(x25)
VX26 x26 0 PWL(0 0.9556 15u 0.9556 15.3u 0 30u 0 30.3u 0.0109 45u 0.0109 45.3u 0.5922 60u 0.5922 60.3u 0.4632 75u 0.4632 75.3u 0.1203)
BNX26 nx26 0 V=-V(x26)
VX27 x27 0 PWL(0 0.3686 15u 0.3686 15.3u 0.0248 30u 0.0248 30.3u 0.7739 45u 0.7739 45.3u 0.7752 60u 0.7752 60.3u 0 75u 0 75.3u 0)
BNX27 nx27 0 V=-V(x27)
VX28 x28 0 PWL(0 0.0044 15u 0.0044 15.3u 0.6383 30u 0.6383 30.3u 0.2627 45u 0.2627 45.3u 0.946 60u 0.946 60.3u 0 75u 0 75.3u 0)
BNX28 nx28 0 V=-V(x28)
VX29 x29 0 PWL(0 0.4806 15u 0.4806 15.3u 0 30u 0 30.3u 0 45u 0 45.3u 0.5207 60u 0.5207 60.3u 0.6558 75u 0.6558 75.3u 0)
BNX29 nx29 0 V=-V(x29)
VX30 x30 0 PWL(0 0.627 15u 0.627 15.3u 0 30u 0 30.3u 0 45u 0 45.3u 0.0431 60u 0.0431 60.3u 0.1133 75u 0.1133 75.3u 0)
BNX30 nx30 0 V=-V(x30)
VX31 x31 0 0
BNX31 nx31 0 V=-V(x31)
VX32 x32 0 0
BNX32 nx32 0 V=-V(x32)
VX33 x33 0 PWL(0 0.1717 15u 0.1717 15.3u 0 30u 0 30.3u 0 45u 0 45.3u 0 60u 0 60.3u 0.2858 75u 0.2858 75.3u 0.932)
BNX33 nx33 0 V=-V(x33)
VX34 x34 0 PWL(0 0.658 15u 0.658 15.3u 0 30u 0 30.3u 0.434 45u 0.434 45.3u 0.1368 60u 0.1368 60.3u 0.4039 75u 0.4039 75.3u 0.6911)
BNX34 nx34 0 V=-V(x34)
VX35 x35 0 PWL(0 0 15u 0 15.3u 0.2401 30u 0.2401 30.3u 0.6514 45u 0.6514 45.3u 0.3137 60u 0.3137 60.3u 0.1111 75u 0.1111 75.3u 0.4601)
BNX35 nx35 0 V=-V(x35)
VX36 x36 0 PWL(0 0.0092 15u 0.0092 15.3u 0.4227 30u 0.4227 30.3u 0 45u 0 45.3u 0.3712 60u 0.3712 60.3u 0.2222 75u 0.2222 75.3u 0.4044)
BNX36 nx36 0 V=-V(x36)
VX37 x37 0 PWL(0 0.4963 15u 0.4963 15.3u 0 30u 0 30.3u 0 45u 0 45.3u 0.532 60u 0.532 60.3u 0.7891 75u 0.7891 75.3u 0.1865)
BNX37 nx37 0 V=-V(x37)
VX38 x38 0 PWL(0 0.7512 15u 0.7512 15.3u 0 30u 0 30.3u 0 45u 0 45.3u 0.8327 60u 0.8327 60.3u 0 75u 0 75.3u 0)
BNX38 nx38 0 V=-V(x38)
VX39 x39 0 PWL(0 0 15u 0 15.3u 0 30u 0 30.3u 0 45u 0 45.3u 0.1007 60u 0.1007 60.3u 0 75u 0 75.3u 0)
BNX39 nx39 0 V=-V(x39)
VX40 x40 0 0
BNX40 nx40 0 V=-V(x40)
VX41 x41 0 PWL(0 0.2841 15u 0.2841 15.3u 0 30u 0 30.3u 0 45u 0 45.3u 0 60u 0 60.3u 0.0179 75u 0.0179 75.3u 0.1194)
BNX41 nx41 0 V=-V(x41)
VX42 x42 0 PWL(0 0.6898 15u 0.6898 15.3u 0 30u 0 30.3u 0.9359 45u 0.9359 45.3u 0.6553 60u 0.6553 60.3u 0.3486 75u 0.3486 75.3u 0.3769)
BNX42 nx42 0 V=-V(x42)
VX43 x43 0 PWL(0 0.2414 15u 0.2414 15.3u 0.5495 30u 0.5495 30.3u 0.1277 45u 0.1277 45.3u 0.305 60u 0.305 60.3u 0.4392 75u 0.4392 75.3u 0.9094)
BNX43 nx43 0 V=-V(x43)
VX44 x44 0 PWL(0 0.5699 15u 0.5699 15.3u 0.1599 30u 0.1599 30.3u 0.0196 45u 0.0196 45.3u 0 60u 0 60.3u 0.4366 75u 0.4366 75.3u 0.8214)
BNX44 nx44 0 V=-V(x44)
VX45 x45 0 PWL(0 0.9869 15u 0.9869 15.3u 0 30u 0 30.3u 0.0109 45u 0.0109 45.3u 0 60u 0 60.3u 0.6824 75u 0.6824 75.3u 0.8675)
BNX45 nx45 0 V=-V(x45)
VX46 x46 0 PWL(0 0.2013 15u 0.2013 15.3u 0 30u 0 30.3u 0.0902 45u 0.0902 45.3u 0.4967 60u 0.4967 60.3u 0 75u 0 75.3u 0)
BNX46 nx46 0 V=-V(x46)
VX47 x47 0 PWL(0 0 15u 0 15.3u 0 30u 0 30.3u 0.1948 45u 0.1948 45.3u 0.5028 60u 0.5028 60.3u 0 75u 0 75.3u 0)
BNX47 nx47 0 V=-V(x47)
VX48 x48 0 0
BNX48 nx48 0 V=-V(x48)
VX49 x49 0 PWL(0 0.0627 15u 0.0627 15.3u 0 30u 0 30.3u 0 45u 0 45.3u 0 60u 0 60.3u 0 75u 0 75.3u 0)
BNX49 nx49 0 V=-V(x49)
VX50 x50 0 PWL(0 0.8479 15u 0.8479 15.3u 0.0044 30u 0.0044 30.3u 0.7298 45u 0.7298 45.3u 0.0932 60u 0.0932 60.3u 0 75u 0 75.3u 0)
BNX50 nx50 0 V=-V(x50)
VX51 x51 0 PWL(0 0.9843 15u 0.9843 15.3u 0.7651 30u 0.7651 30.3u 0.841 45u 0.841 45.3u 0.7102 60u 0.7102 60.3u 0 75u 0 75.3u 0.5176)
BNX51 nx51 0 V=-V(x51)
VX52 x52 0 PWL(0 0.915 15u 0.915 15.3u 0.0301 30u 0.0301 30.3u 0.9551 45u 0.9551 45.3u 0.6627 60u 0.6627 60.3u 0.1699 75u 0.1699 75.3u 0.9399)
BNX52 nx52 0 V=-V(x52)
VX53 x53 0 PWL(0 0.3847 15u 0.3847 15.3u 0 30u 0 30.3u 0.7503 45u 0.7503 45.3u 0.7063 60u 0.7063 60.3u 0.6562 75u 0.6562 75.3u 0.5307)
BNX53 nx53 0 V=-V(x53)
VX54 x54 0 PWL(0 0 15u 0 15.3u 0 30u 0 30.3u 0.6723 45u 0.6723 45.3u 0.8893 60u 0.8893 60.3u 0 75u 0 75.3u 0)
BNX54 nx54 0 V=-V(x54)
VX55 x55 0 PWL(0 0 15u 0 15.3u 0 30u 0 30.3u 0.5063 45u 0.5063 45.3u 0.2789 60u 0.2789 60.3u 0 75u 0 75.3u 0)
BNX55 nx55 0 V=-V(x55)
VX56 x56 0 0
BNX56 nx56 0 V=-V(x56)
VX57 x57 0 0
BNX57 nx57 0 V=-V(x57)
VX58 x58 0 PWL(0 0.0314 15u 0.0314 15.3u 0.0022 30u 0.0022 30.3u 0 45u 0 45.3u 0 60u 0 60.3u 0 75u 0 75.3u 0)
BNX58 nx58 0 V=-V(x58)
VX59 x59 0 PWL(0 0.2606 15u 0.2606 15.3u 0.1673 30u 0.1673 30.3u 0 45u 0 45.3u 0 60u 0 60.3u 0 75u 0 75.3u 0)
BNX59 nx59 0 V=-V(x59)
VX60 x60 0 PWL(0 0.0754 15u 0.0754 15.3u 0 30u 0 30.3u 0 45u 0 45.3u 0.0867 60u 0.0867 60.3u 0.1791 75u 0.1791 75.3u 0.115)
BNX60 nx60 0 V=-V(x60)
VX61 x61 0 PWL(0 0 15u 0 15.3u 0 30u 0 30.3u 0 45u 0 45.3u 0.1255 60u 0.1255 60.3u 0.18 75u 0.18 75.3u 0)
BNX61 nx61 0 V=-V(x61)
VX62 x62 0 PWL(0 0 15u 0 15.3u 0 30u 0 30.3u 0 45u 0 45.3u 0.0192 60u 0.0192 60.3u 0 75u 0 75.3u 0)
BNX62 nx62 0 V=-V(x62)
VX63 x63 0 0
BNX63 nx63 0 V=-V(x63)
* ---- stage 1: 64 -> 48 (hidden, single-supply ReLU)
XS1_0 bS1_0 s1_0 vcc veer a1_0 LT1810
RBALS1_0 bS1_0 0 6.949k
RF1_0 a1_0 s1_0 100k
CFRF1_0 a1_0 s1_0 2p
R1_0_0 x0 s1_0 237k
R1_0_1 nx1 s1_0 150k
R1_0_2 x2 s1_0 715k
R1_0_3 nx3 s1_0 243k
R1_0_4 nx4 s1_0 365k
R1_0_5 nx5 s1_0 453k
R1_0_6 nx6 s1_0 464k
R1_0_7 nx7 s1_0 374k
R1_0_8 nx8 s1_0 866k
R1_0_9 x9 s1_0 158k
R1_0_10 x10 s1_0 249k
R1_0_11 x11 s1_0 499k
R1_0_13 x13 s1_0 866k
R1_0_14 x14 s1_0 866k
R1_0_15 x15 s1_0 887k
R1_0_16 nx16 s1_0 619k
R1_0_17 x17 s1_0 187k
R1_0_18 x18 s1_0 324k
R1_0_19 nx19 s1_0 825k
R1_0_20 x20 s1_0 590k
R1_0_21 nx21 s1_0 845k
R1_0_23 x23 s1_0 243k
R1_0_24 nx24 s1_0 332k
R1_0_25 nx25 s1_0 649k
R1_0_27 x27 s1_0 523k
R1_0_28 nx28 s1_0 210k
R1_0_29 nx29 s1_0 976k
R1_0_30 nx30 s1_0 294k
R1_0_31 x31 s1_0 536k
R1_0_32 nx32 s1_0 316k
R1_0_33 nx33 s1_0 698k
R1_0_34 x34 s1_0 806k
R1_0_35 nx35 s1_0 1.05Meg
R1_0_37 nx37 s1_0 536k
R1_0_38 x38 s1_0 340k
R1_0_39 nx39 s1_0 931k
R1_0_41 nx41 s1_0 1.02Meg
R1_0_42 nx42 s1_0 887k
R1_0_43 x43 s1_0 866k
R1_0_44 nx44 s1_0 255k
R1_0_45 nx45 s1_0 1.1Meg
R1_0_47 nx47 s1_0 619k
R1_0_48 nx48 s1_0 1.02Meg
R1_0_49 nx49 s1_0 475k
R1_0_50 nx50 s1_0 1Meg
R1_0_52 nx52 s1_0 274k
R1_0_53 nx53 s1_0 634k
R1_0_54 nx54 s1_0 210k
R1_0_55 nx55 s1_0 196k
R1_0_56 nx56 s1_0 1.87Meg
R1_0_58 x58 s1_0 1.87Meg
R1_0_59 x59 s1_0 287k
R1_0_60 x60 s1_0 280k
R1_0_61 x61 s1_0 432k
R1_0_62 nx62 s1_0 590k
R1_0_63 x63 s1_0 1.18Meg
RB1_0 bp s1_0 2.1Meg
XI1_0 bI1_0 si1_0 vcc vee na1_0 LT1810
RBALI1_0 bI1_0 0 50k
RIA1_0 a1_0 si1_0 100k
RIF1_0 na1_0 si1_0 100k
CFRIF1_0 na1_0 si1_0 2p
XS1_1 bS1_1 s1_1 vcc veer a1_1 LT1810
RBALS1_1 bS1_1 0 5.77487k
RF1_1 a1_1 s1_1 100k
CFRF1_1 a1_1 s1_1 2p
R1_1_0 nx0 s1_1 178k
R1_1_1 nx1 s1_1 348k
R1_1_2 nx2 s1_1 1.02Meg
R1_1_3 nx3 s1_1 634k
R1_1_4 x4 s1_1 590k
R1_1_5 nx5 s1_1 750k
R1_1_6 nx6 s1_1 1.33Meg
R1_1_8 nx8 s1_1 130k
R1_1_9 nx9 s1_1 402k
R1_1_10 x10 s1_1 681k
R1_1_11 nx11 s1_1 634k
R1_1_12 nx12 s1_1 487k
R1_1_13 nx13 s1_1 698k
R1_1_14 x14 s1_1 866k
R1_1_16 x16 s1_1 845k
R1_1_17 x17 s1_1 487k
R1_1_18 nx18 s1_1 604k
R1_1_19 nx19 s1_1 1.5Meg
R1_1_21 nx21 s1_1 1.43Meg
R1_1_22 nx22 s1_1 536k
R1_1_23 nx23 s1_1 1.27Meg
R1_1_24 x24 s1_1 274k
R1_1_25 x25 s1_1 274k
R1_1_26 nx26 s1_1 1.02Meg
R1_1_27 x27 s1_1 649k
R1_1_28 nx28 s1_1 464k
R1_1_30 nx30 s1_1 200k
R1_1_31 nx31 s1_1 226k
R1_1_32 x32 s1_1 487k
R1_1_33 x33 s1_1 374k
R1_1_34 x34 s1_1 301k
R1_1_35 nx35 s1_1 274k
R1_1_36 nx36 s1_1 226k
R1_1_37 x37 s1_1 1.4Meg
R1_1_38 x38 s1_1 324k
R1_1_39 x39 s1_1 137k
R1_1_40 nx40 s1_1 1.05Meg
R1_1_41 x41 s1_1 309k
R1_1_42 x42 s1_1 162k
R1_1_43 x43 s1_1 511k
R1_1_44 nx44 s1_1 1.1Meg
R1_1_45 x45 s1_1 133k
R1_1_46 x46 s1_1 287k
R1_1_47 x47 s1_1 1.13Meg
R1_1_48 nx48 s1_1 634k
R1_1_49 nx49 s1_1 348k
R1_1_50 x50 s1_1 715k
R1_1_51 nx51 s1_1 1.47Meg
R1_1_52 x52 s1_1 383k
R1_1_53 x53 s1_1 182k
R1_1_54 x54 s1_1 174k
R1_1_56 nx56 s1_1 909k
R1_1_57 nx57 s1_1 301k
R1_1_58 nx58 s1_1 1.96Meg
R1_1_59 nx59 s1_1 1.4Meg
R1_1_60 x60 s1_1 196k
R1_1_61 x61 s1_1 105k
R1_1_62 nx62 s1_1 1.54Meg
R1_1_63 nx63 s1_1 280k
RB1_1 bn s1_1 340k
XI1_1 bI1_1 si1_1 vcc vee na1_1 LT1810
RBALI1_1 bI1_1 0 50k
RIA1_1 a1_1 si1_1 100k
RIF1_1 na1_1 si1_1 100k
CFRIF1_1 na1_1 si1_1 2p
XS1_2 bS1_2 s1_2 vcc veer a1_2 LT1810
RBALS1_2 bS1_2 0 5.35411k
RF1_2 a1_2 s1_2 100k
CFRF1_2 a1_2 s1_2 2p
R1_2_0 nx0 s1_2 1.24Meg
R1_2_1 x1 s1_2 178k
R1_2_2 x2 s1_2 210k
R1_2_3 nx3 s1_2 1.15Meg
R1_2_5 x5 s1_2 365k
R1_2_6 nx6 s1_2 348k
R1_2_7 nx7 s1_2 316k
R1_2_8 nx8 s1_2 374k
R1_2_9 nx9 s1_2 237k
R1_2_10 x10 s1_2 215k
R1_2_11 x11 s1_2 221k
R1_2_12 x12 s1_2 1.1Meg
R1_2_13 nx13 s1_2 499k
R1_2_14 nx14 s1_2 374k
R1_2_15 nx15 s1_2 1.74Meg
R1_2_16 nx16 s1_2 215k
R1_2_17 nx17 s1_2 845k
R1_2_18 nx18 s1_2 511k
R1_2_19 nx19 s1_2 232k
R1_2_20 nx20 s1_2 562k
R1_2_21 nx21 s1_2 374k
R1_2_23 nx23 s1_2 267k
R1_2_24 x24 s1_2 226k
R1_2_25 x25 s1_2 169k
R1_2_28 x28 s1_2 536k
R1_2_31 nx31 s1_2 287k
R1_2_33 x33 s1_2 1.4Meg
R1_2_34 x34 s1_2 475k
R1_2_35 x35 s1_2 511k
R1_2_36 x36 s1_2 887k
R1_2_38 x38 s1_2 357k
R1_2_39 x39 s1_2 130k
R1_2_40 x40 s1_2 732k
R1_2_41 nx41 s1_2 619k
R1_2_42 nx42 s1_2 348k
R1_2_43 x43 s1_2 590k
R1_2_44 nx44 s1_2 274k
R1_2_45 nx45 s1_2 274k
R1_2_46 x46 s1_2 205k
R1_2_47 x47 s1_2 374k
R1_2_48 x48 s1_2 324k
R1_2_49 nx49 s1_2 2Meg
R1_2_50 x50 s1_2 1.96Meg
R1_2_51 nx51 s1_2 634k
R1_2_52 x52 s1_2 2.05Meg
R1_2_54 x54 s1_2 69.8k
R1_2_55 x55 s1_2 196k
R1_2_56 nx56 s1_2 165k
R1_2_57 x57 s1_2 169k
R1_2_58 nx58 s1_2 237k
R1_2_59 nx59 s1_2 267k
R1_2_61 x61 s1_2 294k
R1_2_62 x62 s1_2 150k
R1_2_63 x63 s1_2 348k
RB1_2 bn s1_2 2.26Meg
XI1_2 bI1_2 si1_2 vcc vee na1_2 LT1810
RBALI1_2 bI1_2 0 50k
RIA1_2 a1_2 si1_2 100k
RIF1_2 na1_2 si1_2 100k
CFRIF1_2 na1_2 si1_2 2p
XS1_3 bS1_3 s1_3 vcc veer a1_3 LT1810
RBALS1_3 bS1_3 0 4.36374k
RF1_3 a1_3 s1_3 100k
CFRF1_3 a1_3 s1_3 2p
R1_3_0 nx0 s1_3 137k
R1_3_1 x1 s1_3 287k
R1_3_2 nx2 s1_3 182k
R1_3_3 nx3 s1_3 332k
R1_3_4 x4 s1_3 442k
R1_3_5 nx5 s1_3 806k
R1_3_6 x6 s1_3 340k
R1_3_7 x7 s1_3 294k
R1_3_8 nx8 s1_3 536k
R1_3_9 x9 s1_3 976k
R1_3_10 x10 s1_3 549k
R1_3_11 x11 s1_3 976k
R1_3_12 x12 s1_3 182k
R1_3_13 x13 s1_3 86.6k
R1_3_14 x14 s1_3 97.6k
R1_3_15 x15 s1_3 90.9k
R1_3_16 nx16 s1_3 124k
R1_3_17 nx17 s1_3 294k
R1_3_18 nx18 s1_3 976k
R1_3_19 nx19 s1_3 1.18Meg
R1_3_20 x20 s1_3 412k
R1_3_21 x21 s1_3 422k
R1_3_22 nx22 s1_3 1.15Meg
R1_3_23 x23 s1_3 487k
R1_3_24 nx24 s1_3 309k
R1_3_26 x26 s1_3 499k
R1_3_27 nx27 s1_3 261k
R1_3_28 nx28 s1_3 294k
R1_3_29 nx29 s1_3 340k
R1_3_30 nx30 s1_3 255k
R1_3_31 nx31 s1_3 324k
R1_3_32 x32 s1_3 681k
R1_3_33 x33 s1_3 887k
R1_3_34 x34 s1_3 374k
R1_3_35 nx35 s1_3 825k
R1_3_36 x36 s1_3 287k
R1_3_37 nx37 s1_3 1.3Meg
R1_3_38 nx38 s1_3 324k
R1_3_39 nx39 s1_3 255k
R1_3_40 x40 s1_3 1.69Meg
R1_3_42 nx42 s1_3 549k
R1_3_43 nx43 s1_3 196k
R1_3_44 nx44 s1_3 1.69Meg
R1_3_47 x47 s1_3 1.47Meg
R1_3_48 nx48 s1_3 158k
R1_3_49 x49 s1_3 274k
R1_3_51 x51 s1_3 576k
R1_3_53 x53 s1_3 487k
R1_3_54 x54 s1_3 340k
R1_3_55 x55 s1_3 93.1k
R1_3_56 x56 s1_3 511k
R1_3_57 x57 s1_3 182k
R1_3_58 x58 s1_3 150k
R1_3_59 x59 s1_3 210k
R1_3_60 x60 s1_3 255k
R1_3_61 x61 s1_3 324k
R1_3_62 x62 s1_3 140k
R1_3_63 x63 s1_3 76.8k
RB1_3 bn s1_3 402k
XI1_3 bI1_3 si1_3 vcc vee na1_3 LT1810
RBALI1_3 bI1_3 0 50k
RIA1_3 a1_3 si1_3 100k
RIF1_3 na1_3 si1_3 100k
CFRIF1_3 na1_3 si1_3 2p
XS1_4 bS1_4 s1_4 vcc veer a1_4 LT1810
RBALS1_4 bS1_4 0 7.11388k
RF1_4 a1_4 s1_4 100k
CFRF1_4 a1_4 s1_4 2p
R1_4_1 nx1 s1_4 665k
R1_4_2 nx2 s1_4 576k
R1_4_3 nx3 s1_4 487k
R1_4_4 nx4 s1_4 249k
R1_4_5 nx5 s1_4 154k
R1_4_6 nx6 s1_4 1.21Meg
R1_4_7 x7 s1_4 1.3Meg
R1_4_8 x8 s1_4 294k
R1_4_9 x9 s1_4 732k
R1_4_11 nx11 s1_4 365k
R1_4_12 nx12 s1_4 1.18Meg
R1_4_13 nx13 s1_4 348k
R1_4_14 nx14 s1_4 887k
R1_4_15 nx15 s1_4 442k
R1_4_16 nx16 s1_4 698k
R1_4_17 nx17 s1_4 280k
R1_4_18 x18 s1_4 1.15Meg
R1_4_19 x19 s1_4 316k
R1_4_20 nx20 s1_4 1.62Meg
R1_4_21 nx21 s1_4 909k
R1_4_22 nx22 s1_4 681k
R1_4_23 nx23 s1_4 402k
R1_4_24 nx24 s1_4 215k
R1_4_26 x26 s1_4 3.09Meg
R1_4_28 x28 s1_4 1.05Meg
R1_4_29 x29 s1_4 309k
R1_4_30 nx30 s1_4 280k
R1_4_31 nx31 s1_4 255k
R1_4_32 x32 s1_4 464k
R1_4_33 x33 s1_4 3.4Meg
R1_4_34 x34 s1_4 1Meg
R1_4_35 x35 s1_4 365k
R1_4_36 nx36 s1_4 143k
R1_4_37 x37 s1_4 1.37Meg
R1_4_38 x38 s1_4 374k
R1_4_39 nx39 s1_4 604k
R1_4_40 x40 s1_4 475k
R1_4_41 x41 s1_4 287k
R1_4_42 x42 s1_4 301k
R1_4_43 nx43 s1_4 221k
R1_4_44 nx44 s1_4 634k
R1_4_45 x45 s1_4 825k
R1_4_46 nx46 s1_4 422k
R1_4_47 nx47 s1_4 196k
R1_4_48 nx48 s1_4 1.33Meg
R1_4_49 x49 s1_4 1.5Meg
R1_4_50 nx50 s1_4 464k
R1_4_51 nx51 s1_4 1.87Meg
R1_4_52 x52 s1_4 1.43Meg
R1_4_53 nx53 s1_4 806k
R1_4_54 nx54 s1_4 953k
R1_4_55 nx55 s1_4 619k
R1_4_56 nx56 s1_4 499k
R1_4_57 nx57 s1_4 549k
R1_4_58 nx58 s1_4 348k
R1_4_59 nx59 s1_4 422k
R1_4_61 x61 s1_4 324k
R1_4_62 nx62 s1_4 453k
R1_4_63 nx63 s1_4 665k
RB1_4 bn s1_4 1.5Meg
XI1_4 bI1_4 si1_4 vcc vee na1_4 LT1810
RBALI1_4 bI1_4 0 50k
RIA1_4 a1_4 si1_4 100k
RIF1_4 na1_4 si1_4 100k
CFRIF1_4 na1_4 si1_4 2p
XS1_5 bS1_5 s1_5 vcc veer a1_5 LT1810
RBALS1_5 bS1_5 0 7.36836k
RF1_5 a1_5 s1_5 100k
CFRF1_5 a1_5 s1_5 2p
R1_5_0 x0 s1_5 150k
R1_5_1 nx1 s1_5 215k
R1_5_2 nx2 s1_5 392k
R1_5_3 nx3 s1_5 1.54Meg
R1_5_4 x4 s1_5 453k
R1_5_5 nx5 s1_5 1.37Meg
R1_5_6 x6 s1_5 590k
R1_5_7 nx7 s1_5 499k
R1_5_8 nx8 s1_5 549k
R1_5_9 nx9 s1_5 715k
R1_5_10 nx10 s1_5 243k
R1_5_11 nx11 s1_5 1.33Meg
R1_5_12 nx12 s1_5 316k
R1_5_13 nx13 s1_5 392k
R1_5_14 nx14 s1_5 1.91Meg
R1_5_15 x15 s1_5 787k
R1_5_16 nx16 s1_5 432k
R1_5_17 nx17 s1_5 392k
R1_5_19 x19 s1_5 237k
R1_5_20 x20 s1_5 274k
R1_5_22 nx22 s1_5 1.54Meg
R1_5_23 x23 s1_5 210k
R1_5_24 nx24 s1_5 261k
R1_5_25 nx25 s1_5 374k
R1_5_28 x28 s1_5 191k
R1_5_29 nx29 s1_5 665k
R1_5_30 nx30 s1_5 412k
R1_5_31 nx31 s1_5 178k
R1_5_32 x32 s1_5 1.1Meg
R1_5_33 x33 s1_5 866k
R1_5_34 x34 s1_5 825k
R1_5_35 nx35 s1_5 1.69Meg
R1_5_36 nx36 s1_5 523k
R1_5_37 nx37 s1_5 1.05Meg
R1_5_38 nx38 s1_5 487k
R1_5_41 x41 s1_5 698k
R1_5_42 nx42 s1_5 590k
R1_5_43 nx43 s1_5 324k
R1_5_45 nx45 s1_5 365k
R1_5_46 x46 s1_5 432k
R1_5_47 x47 s1_5 536k
R1_5_48 x48 s1_5 475k
R1_5_49 x49 s1_5 887k
R1_5_50 nx50 s1_5 226k
R1_5_51 nx51 s1_5 340k
R1_5_52 nx52 s1_5 232k
R1_5_53 nx53 s1_5 422k
R1_5_54 nx54 s1_5 887k
R1_5_57 nx57 s1_5 576k
R1_5_58 x58 s1_5 1.4Meg
R1_5_59 nx59 s1_5 374k
R1_5_60 x60 s1_5 1.1Meg
R1_5_61 nx61 s1_5 825k
R1_5_63 nx63 s1_5 511k
XI1_5 bI1_5 si1_5 vcc vee na1_5 LT1810
RBALI1_5 bI1_5 0 50k
RIA1_5 a1_5 si1_5 100k
RIF1_5 na1_5 si1_5 100k
CFRIF1_5 na1_5 si1_5 2p
XS1_6 bS1_6 s1_6 vcc veer a1_6 LT1810
RBALS1_6 bS1_6 0 5.72643k
RF1_6 a1_6 s1_6 100k
CFRF1_6 a1_6 s1_6 2p
R1_6_0 x0 s1_6 147k
R1_6_1 x1 s1_6 205k
R1_6_2 nx2 s1_6 866k
R1_6_3 nx3 s1_6 309k
R1_6_5 x5 s1_6 374k
R1_6_6 nx6 s1_6 604k
R1_6_7 nx7 s1_6 511k
R1_6_8 x8 s1_6 237k
R1_6_9 x9 s1_6 1.37Meg
R1_6_10 nx10 s1_6 1.18Meg
R1_6_11 nx11 s1_6 249k
R1_6_12 nx12 s1_6 365k
R1_6_13 x13 s1_6 158k
R1_6_14 x14 s1_6 232k
R1_6_15 nx15 s1_6 196k
R1_6_16 nx16 s1_6 243k
R1_6_17 nx17 s1_6 1Meg
R1_6_18 nx18 s1_6 619k
R1_6_19 nx19 s1_6 332k
R1_6_20 x20 s1_6 324k
R1_6_21 nx21 s1_6 2.43Meg
R1_6_22 nx22 s1_6 210k
R1_6_24 nx24 s1_6 113k
R1_6_25 nx25 s1_6 665k
R1_6_26 nx26 s1_6 2.37Meg
R1_6_27 nx27 s1_6 182k
R1_6_28 x28 s1_6 226k
R1_6_29 nx29 s1_6 806k
R1_6_30 x30 s1_6 274k
R1_6_31 x31 s1_6 523k
R1_6_32 nx32 s1_6 237k
R1_6_33 x33 s1_6 255k
R1_6_34 nx34 s1_6 590k
R1_6_37 nx37 s1_6 931k
R1_6_38 x38 s1_6 499k
R1_6_40 nx40 s1_6 549k
R1_6_41 nx41 s1_6 887k
R1_6_42 x42 s1_6 523k
R1_6_43 nx43 s1_6 549k
R1_6_44 x44 s1_6 340k
R1_6_45 nx45 s1_6 1.78Meg
R1_6_46 x46 s1_6 1.96Meg
R1_6_47 x47 s1_6 619k
R1_6_48 nx48 s1_6 787k
R1_6_49 x49 s1_6 274k
R1_6_50 x50 s1_6 316k
R1_6_51 x51 s1_6 698k
R1_6_53 nx53 s1_6 442k
R1_6_55 x55 s1_6 124k
R1_6_57 nx57 s1_6 402k
R1_6_58 nx58 s1_6 953k
R1_6_59 nx59 s1_6 332k
R1_6_60 nx60 s1_6 340k
R1_6_61 nx61 s1_6 1.4Meg
R1_6_62 x62 s1_6 464k
R1_6_63 x63 s1_6 110k
RB1_6 bn s1_6 511k
XI1_6 bI1_6 si1_6 vcc vee na1_6 LT1810
RBALI1_6 bI1_6 0 50k
RIA1_6 a1_6 si1_6 100k
RIF1_6 na1_6 si1_6 100k
CFRIF1_6 na1_6 si1_6 2p
XS1_7 bS1_7 s1_7 vcc veer a1_7 LT1810
RBALS1_7 bS1_7 0 5.98121k
RF1_7 a1_7 s1_7 100k
CFRF1_7 a1_7 s1_7 2p
R1_7_0 x0 s1_7 158k
R1_7_1 x1 s1_7 178k
R1_7_2 nx2 s1_7 1.87Meg
R1_7_3 nx3 s1_7 1.5Meg
R1_7_4 x4 s1_7 324k
R1_7_5 nx5 s1_7 237k
R1_7_6 nx6 s1_7 287k
R1_7_7 nx7 s1_7 402k
R1_7_8 x8 s1_7 82.5k
R1_7_9 x9 s1_7 162k
R1_7_10 x10 s1_7 604k
R1_7_11 nx11 s1_7 665k
R1_7_12 x12 s1_7 732k
R1_7_13 x13 s1_7 732k
R1_7_14 nx14 s1_7 392k
R1_7_15 nx15 s1_7 324k
R1_7_16 x16 s1_7 162k
R1_7_17 x17 s1_7 221k
R1_7_18 nx18 s1_7 825k
R1_7_19 nx19 s1_7 511k
R1_7_21 x21 s1_7 243k
R1_7_22 x22 s1_7 294k
R1_7_23 x23 s1_7 536k
R1_7_24 x24 s1_7 590k
R1_7_25 x25 s1_7 619k
R1_7_27 nx27 s1_7 464k
R1_7_28 x28 s1_7 324k
R1_7_29 x29 s1_7 536k
R1_7_30 x30 s1_7 562k
R1_7_32 x32 s1_7 619k
R1_7_35 nx35 s1_7 182k
R1_7_36 x36 s1_7 1.65Meg
R1_7_37 x37 s1_7 402k
R1_7_38 x38 s1_7 1.02Meg
R1_7_39 x39 s1_7 523k
R1_7_40 nx40 s1_7 619k
R1_7_41 nx41 s1_7 392k
R1_7_42 nx42 s1_7 1.62Meg
R1_7_43 nx43 s1_7 1.65Meg
R1_7_44 nx44 s1_7 226k
R1_7_46 nx46 s1_7 249k
R1_7_47 nx47 s1_7 931k
R1_7_49 nx49 s1_7 340k
R1_7_51 nx51 s1_7 324k
R1_7_52 nx52 s1_7 383k
R1_7_53 nx53 s1_7 576k
R1_7_54 nx54 s1_7 442k
R1_7_55 x55 s1_7 187k
R1_7_56 x56 s1_7 294k
R1_7_57 x57 s1_7 332k
R1_7_58 x58 s1_7 845k
R1_7_60 nx60 s1_7 649k
R1_7_61 nx61 s1_7 681k
R1_7_62 nx62 s1_7 732k
R1_7_63 x63 s1_7 221k
RB1_7 bn s1_7 332k
XI1_7 bI1_7 si1_7 vcc vee na1_7 LT1810
RBALI1_7 bI1_7 0 50k
RIA1_7 a1_7 si1_7 100k
RIF1_7 na1_7 si1_7 100k
CFRIF1_7 na1_7 si1_7 2p
XS1_8 bS1_8 s1_8 vcc veer a1_8 LT1810
RBALS1_8 bS1_8 0 7.15357k
RF1_8 a1_8 s1_8 100k
CFRF1_8 a1_8 s1_8 2p
R1_8_0 x0 s1_8 154k
R1_8_1 x1 s1_8 562k
R1_8_2 nx2 s1_8 576k
R1_8_3 x3 s1_8 374k
R1_8_4 nx4 s1_8 576k
R1_8_5 nx5 s1_8 4.75Meg
R1_8_6 x6 s1_8 1.74Meg
R1_8_7 nx7 s1_8 549k
R1_8_8 x8 s1_8 383k
R1_8_9 nx9 s1_8 365k
R1_8_10 x10 s1_8 619k
R1_8_11 x11 s1_8 604k
R1_8_12 x12 s1_8 590k
R1_8_13 nx13 s1_8 909k
R1_8_14 nx14 s1_8 340k
R1_8_15 x15 s1_8 953k
R1_8_16 nx16 s1_8 475k
R1_8_17 nx17 s1_8 267k
R1_8_20 x20 s1_8 150k
R1_8_21 nx21 s1_8 143k
R1_8_22 x22 s1_8 324k
R1_8_24 nx24 s1_8 487k
R1_8_25 x25 s1_8 931k
R1_8_26 x26 s1_8 464k
R1_8_27 nx27 s1_8 787k
R1_8_28 x28 s1_8 402k
R1_8_29 nx29 s1_8 432k
R1_8_30 x30 s1_8 191k
R1_8_31 nx31 s1_8 866k
R1_8_32 nx32 s1_8 1.33Meg
R1_8_34 nx34 s1_8 866k
R1_8_36 nx36 s1_8 536k
R1_8_37 nx37 s1_8 665k
R1_8_38 nx38 s1_8 549k
R1_8_39 nx39 s1_8 422k
R1_8_40 nx40 s1_8 1.47Meg
R1_8_41 x41 s1_8 1.47Meg
R1_8_42 nx42 s1_8 1.21Meg
R1_8_43 x43 s1_8 200k
R1_8_44 nx44 s1_8 511k
R1_8_45 nx45 s1_8 2.1Meg
R1_8_46 x46 s1_8 750k
R1_8_47 nx47 s1_8 442k
R1_8_48 x48 s1_8 432k
R1_8_49 nx49 s1_8 698k
R1_8_50 nx50 s1_8 412k
R1_8_51 x51 s1_8 232k
R1_8_52 x52 s1_8 576k
R1_8_53 nx53 s1_8 412k
R1_8_54 nx54 s1_8 475k
R1_8_55 x55 s1_8 649k
R1_8_56 nx56 s1_8 523k
R1_8_57 nx57 s1_8 649k
R1_8_59 nx59 s1_8 1.18Meg
R1_8_60 x60 s1_8 237k
R1_8_62 nx62 s1_8 205k
R1_8_63 nx63 s1_8 715k
RB1_8 bn s1_8 806k
XI1_8 bI1_8 si1_8 vcc vee na1_8 LT1810
RBALI1_8 bI1_8 0 50k
RIA1_8 a1_8 si1_8 100k
RIF1_8 na1_8 si1_8 100k
CFRIF1_8 na1_8 si1_8 2p
XS1_9 bS1_9 s1_9 vcc veer a1_9 LT1810
RBALS1_9 bS1_9 0 6.00356k
RF1_9 a1_9 s1_9 100k
CFRF1_9 a1_9 s1_9 2p
R1_9_0 nx0 s1_9 137k
R1_9_1 x1 s1_9 787k
R1_9_2 nx2 s1_9 374k
R1_9_3 x3 s1_9 422k
R1_9_4 nx4 s1_9 255k
R1_9_5 nx5 s1_9 499k
R1_9_7 x7 s1_9 118k
R1_9_8 x8 s1_9 205k
R1_9_9 x9 s1_9 698k
R1_9_10 x10 s1_9 787k
R1_9_11 x11 s1_9 487k
R1_9_12 nx12 s1_9 453k
R1_9_13 nx13 s1_9 845k
R1_9_14 x14 s1_9 1.3Meg
R1_9_16 x16 s1_9 154k
R1_9_17 nx17 s1_9 392k
R1_9_18 nx18 s1_9 255k
R1_9_19 nx19 s1_9 432k
R1_9_20 nx20 s1_9 226k
R1_9_21 x21 s1_9 1.47Meg
R1_9_23 nx23 s1_9 261k
R1_9_24 x24 s1_9 442k
R1_9_25 nx25 s1_9 2.21Meg
R1_9_26 x26 s1_9 191k
R1_9_27 x27 s1_9 681k
R1_9_28 nx28 s1_9 196k
R1_9_30 x30 s1_9 931k
R1_9_31 x31 s1_9 1.15Meg
R1_9_32 x32 s1_9 226k
R1_9_34 nx34 s1_9 402k
R1_9_35 nx35 s1_9 392k
R1_9_36 x36 s1_9 1.3Meg
R1_9_37 x37 s1_9 261k
R1_9_38 x38 s1_9 205k
R1_9_39 x39 s1_9 294k
R1_9_40 x40 s1_9 442k
R1_9_41 nx41 s1_9 576k
R1_9_42 nx42 s1_9 232k
R1_9_44 x44 s1_9 453k
R1_9_45 x45 s1_9 1.5Meg
R1_9_46 x46 s1_9 649k
R1_9_47 nx47 s1_9 374k
R1_9_48 nx48 s1_9 133k
R1_9_49 nx49 s1_9 422k
R1_9_50 nx50 s1_9 412k
R1_9_51 x51 s1_9 340k
R1_9_52 x52 s1_9 1.07Meg
R1_9_53 nx53 s1_9 2.67Meg
R1_9_54 nx54 s1_9 953k
R1_9_55 x55 s1_9 267k
R1_9_56 nx56 s1_9 562k
R1_9_58 nx58 s1_9 287k
R1_9_59 nx59 s1_9 681k
R1_9_60 nx60 s1_9 1.69Meg
R1_9_61 nx61 s1_9 1.54Meg
R1_9_62 nx62 s1_9 953k
R1_9_63 nx63 s1_9 332k
RB1_9 bn s1_9 340k
XI1_9 bI1_9 si1_9 vcc vee na1_9 LT1810
RBALI1_9 bI1_9 0 50k
RIA1_9 a1_9 si1_9 100k
RIF1_9 na1_9 si1_9 100k
CFRIF1_9 na1_9 si1_9 2p
XS1_10 bS1_10 s1_10 vcc veer a1_10 LT1810
RBALS1_10 bS1_10 0 5.22673k
RF1_10 a1_10 s1_10 100k
CFRF1_10 a1_10 s1_10 2p
R1_10_0 x0 s1_10 121k
R1_10_1 x1 s1_10 147k
R1_10_2 x2 s1_10 84.5k
R1_10_3 x3 s1_10 169k
R1_10_4 x4 s1_10 221k
R1_10_5 x5 s1_10 402k
R1_10_6 x6 s1_10 1.24Meg
R1_10_7 nx7 s1_10 348k
R1_10_8 nx8 s1_10 1.24Meg
R1_10_9 nx9 s1_10 953k
R1_10_10 x10 s1_10 768k
R1_10_11 nx11 s1_10 1.54Meg
R1_10_13 x13 s1_10 698k
R1_10_14 nx14 s1_10 866k
R1_10_15 nx15 s1_10 309k
R1_10_16 x16 s1_10 715k
R1_10_17 x17 s1_10 464k
R1_10_18 x18 s1_10 392k
R1_10_19 x19 s1_10 576k
R1_10_20 nx20 s1_10 750k
R1_10_21 nx21 s1_10 511k
R1_10_23 nx23 s1_10 1.21Meg
R1_10_24 x24 s1_10 909k
R1_10_25 nx25 s1_10 316k
R1_10_26 nx26 s1_10 442k
R1_10_27 x27 s1_10 412k
R1_10_28 x28 s1_10 274k
R1_10_29 x29 s1_10 332k
R1_10_31 nx31 s1_10 1.74Meg
R1_10_32 nx32 s1_10 232k
R1_10_33 nx33 s1_10 154k
R1_10_34 nx34 s1_10 165k
R1_10_35 x35 s1_10 1.5Meg
R1_10_36 x36 s1_10 348k
R1_10_37 nx37 s1_10 953k
R1_10_38 x38 s1_10 1.15Meg
R1_10_39 x39 s1_10 383k
R1_10_40 x40 s1_10 150k
R1_10_42 nx42 s1_10 232k
R1_10_43 nx43 s1_10 137k
R1_10_44 nx44 s1_10 562k
R1_10_45 nx45 s1_10 549k
R1_10_46 x46 s1_10 536k
R1_10_47 x47 s1_10 237k
R1_10_48 x48 s1_10 137k
R1_10_49 x49 s1_10 255k
R1_10_50 x50 s1_10 150k
R1_10_51 x51 s1_10 196k
R1_10_52 x52 s1_10 1.24Meg
R1_10_54 x54 s1_10 665k
R1_10_55 nx55 s1_10 383k
R1_10_56 nx56 s1_10 237k
R1_10_57 x57 s1_10 665k
R1_10_58 nx58 s1_10 806k
R1_10_60 x60 s1_10 665k
R1_10_61 nx61 s1_10 1.13Meg
R1_10_62 nx62 s1_10 287k
R1_10_63 nx63 s1_10 274k
RB1_10 bn s1_10 365k
XI1_10 bI1_10 si1_10 vcc vee na1_10 LT1810
RBALI1_10 bI1_10 0 50k
RIA1_10 a1_10 si1_10 100k
RIF1_10 na1_10 si1_10 100k
CFRIF1_10 na1_10 si1_10 2p
XS1_11 bS1_11 s1_11 vcc veer a1_11 LT1810
RBALS1_11 bS1_11 0 4.25377k
RF1_11 a1_11 s1_11 100k
CFRF1_11 a1_11 s1_11 2p
R1_11_0 nx0 s1_11 178k
R1_11_1 nx1 s1_11 392k
R1_11_2 nx2 s1_11 249k
R1_11_3 x3 s1_11 549k
R1_11_4 nx4 s1_11 2.8Meg
R1_11_5 nx5 s1_11 191k
R1_11_6 nx6 s1_11 158k
R1_11_7 x7 s1_11 182k
R1_11_8 nx8 s1_11 931k
R1_11_9 x9 s1_11 261k
R1_11_10 nx10 s1_11 1.13Meg
R1_11_11 x11 s1_11 787k
R1_11_12 x12 s1_11 2.1Meg
R1_11_13 x13 s1_11 294k
R1_11_14 x14 s1_11 1.54Meg
R1_11_15 nx15 s1_11 750k
R1_11_16 x16 s1_11 294k
R1_11_17 x17 s1_11 261k
R1_11_18 x18 s1_11 732k
R1_11_19 x19 s1_11 316k
R1_11_21 nx21 s1_11 604k
R1_11_22 nx22 s1_11 681k
R1_11_23 nx23 s1_11 226k
R1_11_24 nx24 s1_11 590k
R1_11_25 nx25 s1_11 1.5Meg
R1_11_27 x27 s1_11 261k
R1_11_28 nx28 s1_11 348k
R1_11_29 x29 s1_11 1.05Meg
R1_11_31 nx31 s1_11 215k
R1_11_32 nx32 s1_11 118k
R1_11_33 x33 s1_11 523k
R1_11_34 x34 s1_11 196k
R1_11_35 x35 s1_11 649k
R1_11_36 nx36 s1_11 357k
R1_11_37 nx37 s1_11 511k
R1_11_38 x38 s1_11 1.07Meg
R1_11_39 x39 s1_11 78.7k
R1_11_40 nx40 s1_11 249k
R1_11_41 nx41 s1_11 332k
R1_11_42 nx42 s1_11 562k
R1_11_43 nx43 s1_11 383k
R1_11_44 nx44 s1_11 750k
R1_11_45 nx45 s1_11 332k
R1_11_46 x46 s1_11 147k
R1_11_47 x47 s1_11 137k
R1_11_48 x48 s1_11 196k
R1_11_50 nx50 s1_11 402k
R1_11_51 nx51 s1_11 316k
R1_11_52 nx52 s1_11 357k
R1_11_53 x53 s1_11 549k
R1_11_54 x54 s1_11 88.7k
R1_11_55 x55 s1_11 301k
R1_11_56 nx56 s1_11 261k
R1_11_57 x57 s1_11 82.5k
R1_11_58 x58 s1_11 105k
R1_11_59 x59 s1_11 432k
R1_11_60 x60 s1_11 412k
R1_11_61 x61 s1_11 82.5k
R1_11_62 x62 s1_11 147k
R1_11_63 x63 s1_11 511k
RB1_11 bn s1_11 2.55Meg
XI1_11 bI1_11 si1_11 vcc vee na1_11 LT1810
RBALI1_11 bI1_11 0 50k
RIA1_11 a1_11 si1_11 100k
RIF1_11 na1_11 si1_11 100k
CFRIF1_11 na1_11 si1_11 2p
XS1_12 bS1_12 s1_12 vcc veer a1_12 LT1810
RBALS1_12 bS1_12 0 5.9351k
RF1_12 a1_12 s1_12 100k
CFRF1_12 a1_12 s1_12 2p
R1_12_0 nx0 s1_12 143k
R1_12_1 nx1 s1_12 121k
R1_12_2 nx2 s1_12 511k
R1_12_4 nx4 s1_12 953k
R1_12_5 nx5 s1_12 280k
R1_12_6 nx6 s1_12 523k
R1_12_7 x7 s1_12 348k
R1_12_8 x8 s1_12 316k
R1_12_9 x9 s1_12 340k
R1_12_10 nx10 s1_12 523k
R1_12_11 nx11 s1_12 357k
R1_12_12 nx12 s1_12 665k
R1_12_13 nx13 s1_12 1Meg
R1_12_15 x15 s1_12 931k
R1_12_17 x17 s1_12 1.37Meg
R1_12_18 nx18 s1_12 453k
R1_12_19 x19 s1_12 422k
R1_12_21 nx21 s1_12 374k
R1_12_22 nx22 s1_12 1.1Meg
R1_12_23 x23 s1_12 523k
R1_12_24 x24 s1_12 210k
R1_12_25 nx25 s1_12 499k
R1_12_26 nx26 s1_12 340k
R1_12_27 nx27 s1_12 287k
R1_12_28 nx28 s1_12 196k
R1_12_29 nx29 s1_12 432k
R1_12_30 nx30 s1_12 316k
R1_12_31 nx31 s1_12 825k
R1_12_32 x32 s1_12 464k
R1_12_33 x33 s1_12 124k
R1_12_34 x34 s1_12 280k
R1_12_35 nx35 s1_12 348k
R1_12_36 nx36 s1_12 432k
R1_12_37 nx37 s1_12 511k
R1_12_38 x38 s1_12 953k
R1_12_39 nx39 s1_12 226k
R1_12_40 nx40 s1_12 487k
R1_12_42 x42 s1_12 127k
R1_12_43 x43 s1_12 118k
R1_12_44 x44 s1_12 169k
R1_12_46 x46 s1_12 536k
R1_12_47 x47 s1_12 845k
R1_12_48 nx48 s1_12 255k
R1_12_50 nx50 s1_12 1.82Meg
R1_12_51 x51 s1_12 1.37Meg
R1_12_53 nx53 s1_12 887k
R1_12_54 nx54 s1_12 383k
R1_12_55 x55 s1_12 215k
R1_12_56 nx56 s1_12 475k
R1_12_57 x57 s1_12 357k
R1_12_59 x59 s1_12 442k
R1_12_60 x60 s1_12 487k
R1_12_61 x61 s1_12 1.1Meg
R1_12_62 x62 s1_12 442k
R1_12_63 x63 s1_12 931k
RB1_12 bp s1_12 1.18Meg
XI1_12 bI1_12 si1_12 vcc vee na1_12 LT1810
RBALI1_12 bI1_12 0 50k
RIA1_12 a1_12 si1_12 100k
RIF1_12 na1_12 si1_12 100k
CFRIF1_12 na1_12 si1_12 2p
XS1_13 bS1_13 s1_13 vcc veer a1_13 LT1810
RBALS1_13 bS1_13 0 4.69k
RF1_13 a1_13 s1_13 100k
CFRF1_13 a1_13 s1_13 2p
R1_13_0 x0 s1_13 274k
R1_13_1 x1 s1_13 130k
R1_13_2 x2 s1_13 100k
R1_13_3 x3 s1_13 154k
R1_13_4 x4 s1_13 113k
R1_13_5 x5 s1_13 143k
R1_13_6 x6 s1_13 249k
R1_13_7 x7 s1_13 84.5k
R1_13_8 x8 s1_13 365k
R1_13_9 nx9 s1_13 187k
R1_13_10 nx10 s1_13 681k
R1_13_11 x11 s1_13 340k
R1_13_12 x12 s1_13 365k
R1_13_13 nx13 s1_13 243k
R1_13_14 x14 s1_13 562k
R1_13_15 x15 s1_13 1Meg
R1_13_16 nx16 s1_13 237k
R1_13_17 nx17 s1_13 750k
R1_13_18 nx18 s1_13 294k
R1_13_19 x19 s1_13 422k
R1_13_20 nx20 s1_13 1.65Meg
R1_13_21 x21 s1_13 1.27Meg
R1_13_22 x22 s1_13 787k
R1_13_23 x23 s1_13 1.91Meg
R1_13_25 x25 s1_13 511k
R1_13_26 nx26 s1_13 464k
R1_13_27 x27 s1_13 845k
R1_13_29 x29 s1_13 1.78Meg
R1_13_30 x30 s1_13 1.58Meg
R1_13_31 x31 s1_13 301k
R1_13_32 nx32 s1_13 715k
R1_13_33 nx33 s1_13 1.37Meg
R1_13_34 nx34 s1_13 464k
R1_13_35 x35 s1_13 475k
R1_13_36 nx36 s1_13 619k
R1_13_37 nx37 s1_13 232k
R1_13_38 x38 s1_13 732k
R1_13_39 nx39 s1_13 536k
R1_13_40 nx40 s1_13 953k
R1_13_41 nx41 s1_13 357k
R1_13_42 x42 s1_13 1.18Meg
R1_13_43 x43 s1_13 200k
R1_13_44 nx44 s1_13 237k
R1_13_45 x45 s1_13 681k
R1_13_46 x46 s1_13 442k
R1_13_47 x47 s1_13 232k
R1_13_48 nx48 s1_13 475k
R1_13_49 x49 s1_13 143k
R1_13_50 x50 s1_13 412k
R1_13_51 x51 s1_13 1.18Meg
R1_13_52 nx52 s1_13 215k
R1_13_53 x53 s1_13 280k
R1_13_54 x54 s1_13 154k
R1_13_55 nx55 s1_13 464k
R1_13_56 nx56 s1_13 511k
R1_13_57 x57 s1_13 95.3k
R1_13_58 x58 s1_13 143k
R1_13_59 x59 s1_13 698k
R1_13_60 nx60 s1_13 309k
R1_13_62 x62 s1_13 237k
R1_13_63 x63 s1_13 464k
XI1_13 bI1_13 si1_13 vcc vee na1_13 LT1810
RBALI1_13 bI1_13 0 50k
RIA1_13 a1_13 si1_13 100k
RIF1_13 na1_13 si1_13 100k
CFRIF1_13 na1_13 si1_13 2p
XS1_14 bS1_14 s1_14 vcc veer a1_14 LT1810
RBALS1_14 bS1_14 0 6.17929k
RF1_14 a1_14 s1_14 100k
CFRF1_14 a1_14 s1_14 2p
R1_14_0 nx0 s1_14 169k
R1_14_1 x1 s1_14 187k
R1_14_2 x2 s1_14 499k
R1_14_3 nx3 s1_14 383k
R1_14_4 nx4 s1_14 348k
R1_14_5 nx5 s1_14 221k
R1_14_7 x7 s1_14 100k
R1_14_8 x8 s1_14 196k
R1_14_11 nx11 s1_14 191k
R1_14_12 nx12 s1_14 931k
R1_14_13 x13 s1_14 1.96Meg
R1_14_15 x15 s1_14 1.82Meg
R1_14_16 x16 s1_14 549k
R1_14_17 x17 s1_14 845k
R1_14_18 nx18 s1_14 243k
R1_14_19 nx19 s1_14 243k
R1_14_20 x20 s1_14 665k
R1_14_21 x21 s1_14 698k
R1_14_23 x23 s1_14 2.15Meg
R1_14_24 nx24 s1_14 232k
R1_14_25 nx25 s1_14 348k
R1_14_26 nx26 s1_14 165k
R1_14_27 x27 s1_14 178k
R1_14_28 x28 s1_14 768k
R1_14_31 nx31 s1_14 215k
R1_14_32 nx32 s1_14 280k
R1_14_33 nx33 s1_14 287k
R1_14_34 nx34 s1_14 887k
R1_14_35 x35 s1_14 267k
R1_14_36 x36 s1_14 432k
R1_14_37 x37 s1_14 348k
R1_14_38 nx38 s1_14 511k
R1_14_39 nx39 s1_14 316k
R1_14_40 x40 s1_14 511k
R1_14_41 nx41 s1_14 715k
R1_14_42 nx42 s1_14 634k
R1_14_43 x43 s1_14 237k
R1_14_44 x44 s1_14 806k
R1_14_45 nx45 s1_14 1.37Meg
R1_14_46 nx46 s1_14 357k
R1_14_47 x47 s1_14 316k
R1_14_48 nx48 s1_14 267k
R1_14_49 nx49 s1_14 768k
R1_14_50 x50 s1_14 1.4Meg
R1_14_51 x51 s1_14 549k
R1_14_52 nx52 s1_14 576k
R1_14_53 nx53 s1_14 750k
R1_14_55 nx55 s1_14 464k
R1_14_56 x56 s1_14 287k
R1_14_57 x57 s1_14 255k
R1_14_59 x59 s1_14 866k
R1_14_60 nx60 s1_14 442k
R1_14_61 nx61 s1_14 1.24Meg
R1_14_62 nx62 s1_14 523k
RB1_14 bn s1_14 1.05Meg
XI1_14 bI1_14 si1_14 vcc vee na1_14 LT1810
RBALI1_14 bI1_14 0 50k
RIA1_14 a1_14 si1_14 100k
RIF1_14 na1_14 si1_14 100k
CFRIF1_14 na1_14 si1_14 2p
XS1_15 bS1_15 s1_15 vcc veer a1_15 LT1810
RBALS1_15 bS1_15 0 5.09957k
RF1_15 a1_15 s1_15 100k
CFRF1_15 a1_15 s1_15 2p
R1_15_0 x0 s1_15 287k
R1_15_1 nx1 s1_15 681k
R1_15_2 x2 s1_15 383k
R1_15_4 nx4 s1_15 665k
R1_15_5 x5 s1_15 549k
R1_15_6 x6 s1_15 442k
R1_15_7 x7 s1_15 806k
R1_15_8 nx8 s1_15 105k
R1_15_10 x10 s1_15 383k
R1_15_11 x11 s1_15 499k
R1_15_12 nx12 s1_15 523k
R1_15_14 x14 s1_15 165k
R1_15_15 x15 s1_15 113k
R1_15_18 x18 s1_15 249k
R1_15_19 x19 s1_15 422k
R1_15_20 nx20 s1_15 205k
R1_15_21 x21 s1_15 287k
R1_15_22 x22 s1_15 249k
R1_15_24 x24 s1_15 105k
R1_15_25 nx25 s1_15 1.3Meg
R1_15_27 nx27 s1_15 309k
R1_15_28 x28 s1_15 1.02Meg
R1_15_29 x29 s1_15 1.3Meg
R1_15_30 x30 s1_15 205k
R1_15_31 x31 s1_15 280k
R1_15_32 x32 s1_15 255k
R1_15_33 nx33 s1_15 1.1Meg
R1_15_34 nx34 s1_15 1.24Meg
R1_15_35 x35 s1_15 340k
R1_15_36 x36 s1_15 1.02Meg
R1_15_38 x38 s1_15 2.74Meg
R1_15_39 nx39 s1_15 210k
R1_15_40 x40 s1_15 97.6k
R1_15_41 nx41 s1_15 3.24Meg
R1_15_42 x42 s1_15 1.21Meg
R1_15_43 nx43 s1_15 1.37Meg
R1_15_44 nx44 s1_15 221k
R1_15_45 nx45 s1_15 866k
R1_15_46 nx46 s1_15 562k
R1_15_47 nx47 s1_15 432k
R1_15_48 x48 s1_15 73.2k
R1_15_49 x49 s1_15 374k
R1_15_50 nx50 s1_15 340k
R1_15_51 nx51 s1_15 357k
R1_15_52 nx52 s1_15 562k
R1_15_53 nx53 s1_15 340k
R1_15_54 nx54 s1_15 806k
R1_15_55 nx55 s1_15 158k
R1_15_56 x56 s1_15 165k
R1_15_57 nx57 s1_15 549k
R1_15_58 nx58 s1_15 374k
R1_15_59 x59 s1_15 237k
R1_15_60 x60 s1_15 162k
R1_15_61 x61 s1_15 324k
R1_15_62 nx62 s1_15 649k
R1_15_63 nx63 s1_15 576k
XI1_15 bI1_15 si1_15 vcc vee na1_15 LT1810
RBALI1_15 bI1_15 0 50k
RIA1_15 a1_15 si1_15 100k
RIF1_15 na1_15 si1_15 100k
CFRIF1_15 na1_15 si1_15 2p
XS1_16 bS1_16 s1_16 vcc veer a1_16 LT1810
RBALS1_16 bS1_16 0 5.37151k
RF1_16 a1_16 s1_16 100k
CFRF1_16 a1_16 s1_16 2p
R1_16_0 x0 s1_16 237k
R1_16_1 x1 s1_16 316k
R1_16_2 x2 s1_16 84.5k
R1_16_3 x3 s1_16 294k
R1_16_5 x5 s1_16 221k
R1_16_6 x6 s1_16 845k
R1_16_7 x7 s1_16 287k
R1_16_8 x8 s1_16 174k
R1_16_9 x9 s1_16 162k
R1_16_10 x10 s1_16 154k
R1_16_12 nx12 s1_16 442k
R1_16_13 x13 s1_16 412k
R1_16_16 x16 s1_16 301k
R1_16_17 x17 s1_16 215k
R1_16_18 x18 s1_16 105k
R1_16_19 nx19 s1_16 324k
R1_16_20 nx20 s1_16 432k
R1_16_21 x21 s1_16 1.1Meg
R1_16_22 x22 s1_16 1.24Meg
R1_16_23 nx23 s1_16 226k
R1_16_24 nx24 s1_16 348k
R1_16_25 x25 s1_16 93.1k
R1_16_26 x26 s1_16 348k
R1_16_27 nx27 s1_16 196k
R1_16_28 nx28 s1_16 1.82Meg
R1_16_29 x29 s1_16 237k
R1_16_30 x30 s1_16 374k
R1_16_31 nx31 s1_16 464k
R1_16_32 x32 s1_16 392k
R1_16_33 x33 s1_16 357k
R1_16_35 x35 s1_16 422k
R1_16_36 nx36 s1_16 511k
R1_16_37 x37 s1_16 511k
R1_16_38 nx38 s1_16 887k
R1_16_40 nx40 s1_16 1.54Meg
R1_16_41 x41 s1_16 866k
R1_16_42 nx42 s1_16 768k
R1_16_43 nx43 s1_16 1.13Meg
R1_16_44 nx44 s1_16 324k
R1_16_45 x45 s1_16 768k
R1_16_46 nx46 s1_16 715k
R1_16_47 nx47 s1_16 309k
R1_16_48 x48 s1_16 348k
R1_16_49 nx49 s1_16 2.32Meg
R1_16_50 nx50 s1_16 374k
R1_16_51 x51 s1_16 1.82Meg
R1_16_52 nx52 s1_16 1.02Meg
R1_16_53 nx53 s1_16 1.74Meg
R1_16_54 x54 s1_16 215k
R1_16_56 x56 s1_16 267k
R1_16_57 x57 s1_16 287k
R1_16_58 nx58 s1_16 340k
R1_16_60 x60 s1_16 909k
R1_16_62 x62 s1_16 196k
R1_16_63 nx63 s1_16 221k
RB1_16 bn s1_16 619k
XI1_16 bI1_16 si1_16 vcc vee na1_16 LT1810
RBALI1_16 bI1_16 0 50k
RIA1_16 a1_16 si1_16 100k
RIF1_16 na1_16 si1_16 100k
CFRIF1_16 na1_16 si1_16 2p
XS1_17 bS1_17 s1_17 vcc veer a1_17 LT1810
RBALS1_17 bS1_17 0 5.68771k
RF1_17 a1_17 s1_17 100k
CFRF1_17 a1_17 s1_17 2p
R1_17_0 nx0 s1_17 536k
R1_17_2 nx2 s1_17 1.18Meg
R1_17_3 x3 s1_17 374k
R1_17_5 nx5 s1_17 1.62Meg
R1_17_6 x6 s1_17 316k
R1_17_7 nx7 s1_17 750k
R1_17_8 x8 s1_17 768k
R1_17_9 x9 s1_17 1.74Meg
R1_17_10 nx10 s1_17 536k
R1_17_11 x11 s1_17 2.26Meg
R1_17_12 nx12 s1_17 1.82Meg
R1_17_13 nx13 s1_17 523k
R1_17_14 nx14 s1_17 2.26Meg
R1_17_15 nx15 s1_17 681k
R1_17_16 nx16 s1_17 953k
R1_17_17 nx17 s1_17 205k
R1_17_18 nx18 s1_17 499k
R1_17_19 nx19 s1_17 226k
R1_17_20 nx20 s1_17 562k
R1_17_21 x21 s1_17 324k
R1_17_22 x22 s1_17 187k
R1_17_23 x23 s1_17 1.07Meg
R1_17_24 x24 s1_17 374k
R1_17_25 x25 s1_17 750k
R1_17_26 x26 s1_17 255k
R1_17_27 x27 s1_17 280k
R1_17_28 x28 s1_17 787k
R1_17_29 nx29 s1_17 383k
R1_17_30 x30 s1_17 1.02Meg
R1_17_31 x31 s1_17 105k
R1_17_32 x32 s1_17 137k
R1_17_33 x33 s1_17 182k
R1_17_34 x34 s1_17 825k
R1_17_38 nx38 s1_17 249k
R1_17_39 nx39 s1_17 150k
R1_17_40 nx40 s1_17 750k
R1_17_41 x41 s1_17 392k
R1_17_42 x42 s1_17 357k
R1_17_43 x43 s1_17 110k
R1_17_44 x44 s1_17 1.13Meg
R1_17_45 nx45 s1_17 1.15Meg
R1_17_46 nx46 s1_17 392k
R1_17_47 nx47 s1_17 210k
R1_17_48 nx48 s1_17 226k
R1_17_49 nx49 s1_17 576k
R1_17_50 nx50 s1_17 681k
R1_17_51 nx51 s1_17 412k
R1_17_52 nx52 s1_17 255k
R1_17_53 nx53 s1_17 432k
R1_17_55 nx55 s1_17 464k
R1_17_56 nx56 s1_17 110k
R1_17_57 nx57 s1_17 232k
R1_17_58 nx58 s1_17 392k
R1_17_59 nx59 s1_17 243k
R1_17_60 nx60 s1_17 2.21Meg
R1_17_61 x61 s1_17 887k
R1_17_62 x62 s1_17 255k
R1_17_63 nx63 s1_17 432k
RB1_17 bp s1_17 665k
XI1_17 bI1_17 si1_17 vcc vee na1_17 LT1810
RBALI1_17 bI1_17 0 50k
RIA1_17 a1_17 si1_17 100k
RIF1_17 na1_17 si1_17 100k
CFRIF1_17 na1_17 si1_17 2p
XS1_18 bS1_18 s1_18 vcc veer a1_18 LT1810
RBALS1_18 bS1_18 0 5.69134k
RF1_18 a1_18 s1_18 100k
CFRF1_18 a1_18 s1_18 2p
R1_18_0 nx0 s1_18 140k
R1_18_1 x1 s1_18 1.5Meg
R1_18_2 nx2 s1_18 825k
R1_18_3 nx3 s1_18 604k
R1_18_4 x4 s1_18 1.1Meg
R1_18_5 x5 s1_18 715k
R1_18_6 x6 s1_18 649k
R1_18_7 x7 s1_18 110k
R1_18_8 nx8 s1_18 562k
R1_18_9 nx9 s1_18 205k
R1_18_10 nx10 s1_18 402k
R1_18_11 nx11 s1_18 255k
R1_18_12 nx12 s1_18 143k
R1_18_14 x14 s1_18 576k
R1_18_15 x15 s1_18 115k
R1_18_16 nx16 s1_18 1.54Meg
R1_18_17 nx17 s1_18 1.24Meg
R1_18_18 nx18 s1_18 357k
R1_18_20 nx20 s1_18 590k
R1_18_21 nx21 s1_18 196k
R1_18_22 nx22 s1_18 649k
R1_18_23 x23 s1_18 499k
R1_18_24 x24 s1_18 226k
R1_18_25 x25 s1_18 274k
R1_18_26 x26 s1_18 154k
R1_18_27 x27 s1_18 196k
R1_18_28 x28 s1_18 2.43Meg
R1_18_29 nx29 s1_18 806k
R1_18_30 nx30 s1_18 649k
R1_18_31 x31 s1_18 205k
R1_18_32 x32 s1_18 604k
R1_18_33 x33 s1_18 365k
R1_18_34 x34 s1_18 536k
R1_18_35 nx35 s1_18 953k
R1_18_36 x36 s1_18 511k
R1_18_38 nx38 s1_18 1.78Meg
R1_18_39 nx39 s1_18 806k
R1_18_40 x40 s1_18 348k
R1_18_41 x41 s1_18 787k
R1_18_43 nx43 s1_18 665k
R1_18_44 x44 s1_18 511k
R1_18_45 x45 s1_18 549k
R1_18_46 x46 s1_18 301k
R1_18_47 nx47 s1_18 562k
R1_18_48 nx48 s1_18 487k
R1_18_49 nx49 s1_18 590k
R1_18_50 x50 s1_18 2.1Meg
R1_18_51 nx51 s1_18 1.91Meg
R1_18_52 nx52 s1_18 523k
R1_18_53 x53 s1_18 1.24Meg
R1_18_54 nx54 s1_18 392k
R1_18_55 nx55 s1_18 1.5Meg
R1_18_56 nx56 s1_18 215k
R1_18_57 nx57 s1_18 118k
R1_18_58 nx58 s1_18 357k
R1_18_59 x59 s1_18 931k
R1_18_60 nx60 s1_18 226k
R1_18_61 nx61 s1_18 294k
R1_18_62 nx62 s1_18 357k
R1_18_63 nx63 s1_18 187k
XI1_18 bI1_18 si1_18 vcc vee na1_18 LT1810
RBALI1_18 bI1_18 0 50k
RIA1_18 a1_18 si1_18 100k
RIF1_18 na1_18 si1_18 100k
CFRIF1_18 na1_18 si1_18 2p
XS1_19 bS1_19 s1_19 vcc veer a1_19 LT1810
RBALS1_19 bS1_19 0 4.72405k
RF1_19 a1_19 s1_19 100k
CFRF1_19 a1_19 s1_19 2p
R1_19_0 x0 s1_19 196k
R1_19_1 x1 s1_19 2.87Meg
R1_19_2 x2 s1_19 76.8k
R1_19_3 x3 s1_19 174k
R1_19_4 x4 s1_19 475k
R1_19_5 x5 s1_19 169k
R1_19_6 x6 s1_19 274k
R1_19_7 x7 s1_19 226k
R1_19_9 x9 s1_19 1.13Meg
R1_19_10 x10 s1_19 1.5Meg
R1_19_11 x11 s1_19 499k
R1_19_12 nx12 s1_19 442k
R1_19_13 x13 s1_19 1.18Meg
R1_19_14 x14 s1_19 187k
R1_19_15 x15 s1_19 127k
R1_19_16 x16 s1_19 1.27Meg
R1_19_17 nx17 s1_19 221k
R1_19_18 nx18 s1_19 392k
R1_19_19 nx19 s1_19 681k
R1_19_20 nx20 s1_19 402k
R1_19_21 nx21 s1_19 1.3Meg
R1_19_22 x22 s1_19 619k
R1_19_23 x23 s1_19 280k
R1_19_24 nx24 s1_19 158k
R1_19_25 nx25 s1_19 255k
R1_19_26 x26 s1_19 1.78Meg
R1_19_27 x27 s1_19 150k
R1_19_28 nx28 s1_19 649k
R1_19_29 nx29 s1_19 196k
R1_19_30 x30 s1_19 576k
R1_19_31 x31 s1_19 118k
R1_19_32 nx32 s1_19 324k
R1_19_33 x33 s1_19 576k
R1_19_35 x35 s1_19 348k
R1_19_36 nx36 s1_19 511k
R1_19_37 nx37 s1_19 806k
R1_19_39 x39 s1_19 698k
R1_19_40 x40 s1_19 1.05Meg
R1_19_41 x41 s1_19 1.21Meg
R1_19_42 x42 s1_19 442k
R1_19_43 x43 s1_19 536k
R1_19_44 nx44 s1_19 475k
R1_19_47 x47 s1_19 97.6k
R1_19_48 nx48 s1_19 665k
R1_19_49 x49 s1_19 88.7k
R1_19_50 x50 s1_19 301k
R1_19_51 x51 s1_19 562k
R1_19_52 x52 s1_19 909k
R1_19_53 nx53 s1_19 1.13Meg
R1_19_54 x54 s1_19 619k
R1_19_55 nx55 s1_19 210k
R1_19_56 x56 s1_19 97.6k
R1_19_57 nx57 s1_19 732k
R1_19_58 nx58 s1_19 619k
R1_19_59 x59 s1_19 665k
R1_19_60 nx60 s1_19 806k
R1_19_61 nx61 s1_19 174k
R1_19_62 nx62 s1_19 523k
R1_19_63 nx63 s1_19 137k
RB1_19 bn s1_19 619k
XI1_19 bI1_19 si1_19 vcc vee na1_19 LT1810
RBALI1_19 bI1_19 0 50k
RIA1_19 a1_19 si1_19 100k
RIF1_19 na1_19 si1_19 100k
CFRIF1_19 na1_19 si1_19 2p
XS1_20 bS1_20 s1_20 vcc veer a1_20 LT1810
RBALS1_20 bS1_20 0 5.85529k
RF1_20 a1_20 s1_20 100k
CFRF1_20 a1_20 s1_20 2p
R1_20_0 nx0 s1_20 162k
R1_20_1 x1 s1_20 130k
R1_20_2 x2 s1_20 210k
R1_20_3 x3 s1_20 102k
R1_20_4 x4 s1_20 383k
R1_20_5 x5 s1_20 453k
R1_20_6 x6 s1_20 140k
R1_20_7 x7 s1_20 261k
R1_20_8 nx8 s1_20 1.15Meg
R1_20_9 x9 s1_20 453k
R1_20_11 x11 s1_20 1.3Meg
R1_20_12 x12 s1_20 422k
R1_20_13 nx13 s1_20 1.87Meg
R1_20_15 x15 s1_20 649k
R1_20_16 nx16 s1_20 590k
R1_20_17 nx17 s1_20 536k
R1_20_18 nx18 s1_20 1.74Meg
R1_20_19 nx19 s1_20 200k
R1_20_20 nx20 s1_20 137k
R1_20_21 nx21 s1_20 178k
R1_20_22 nx22 s1_20 182k
R1_20_23 x23 s1_20 1.65Meg
R1_20_24 x24 s1_20 287k
R1_20_25 nx25 s1_20 3.65Meg
R1_20_26 nx26 s1_20 1.18Meg
R1_20_27 x27 s1_20 1.74Meg
R1_20_28 x28 s1_20 237k
R1_20_29 x29 s1_20 205k
R1_20_30 x30 s1_20 1.3Meg
R1_20_32 x32 s1_20 499k
R1_20_33 nx33 s1_20 1.47Meg
R1_20_34 x34 s1_20 1.24Meg
R1_20_35 x35 s1_20 348k
R1_20_36 x36 s1_20 280k
R1_20_37 nx37 s1_20 665k
R1_20_38 x38 s1_20 453k
R1_20_39 nx39 s1_20 287k
R1_20_40 x40 s1_20 191k
R1_20_41 nx41 s1_20 562k
R1_20_42 nx42 s1_20 536k
R1_20_43 x43 s1_20 845k
R1_20_44 nx44 s1_20 2.21Meg
R1_20_46 nx46 s1_20 604k
R1_20_47 nx47 s1_20 324k
R1_20_48 x48 s1_20 549k
R1_20_49 nx49 s1_20 768k
R1_20_50 nx50 s1_20 909k
R1_20_51 nx51 s1_20 2Meg
R1_20_52 x52 s1_20 1.54Meg
R1_20_53 x53 s1_20 357k
R1_20_54 x54 s1_20 340k
R1_20_55 x55 s1_20 412k
R1_20_56 nx56 s1_20 121k
R1_20_57 x57 s1_20 768k
R1_20_58 x58 s1_20 1.62Meg
R1_20_60 x60 s1_20 523k
R1_20_61 nx61 s1_20 1.02Meg
R1_20_62 x62 s1_20 1.24Meg
R1_20_63 nx63 s1_20 255k
RB1_20 bn s1_20 750k
XI1_20 bI1_20 si1_20 vcc vee na1_20 LT1810
RBALI1_20 bI1_20 0 50k
RIA1_20 a1_20 si1_20 100k
RIF1_20 na1_20 si1_20 100k
CFRIF1_20 na1_20 si1_20 2p
XS1_21 bS1_21 s1_21 vcc veer a1_21 LT1810
RBALS1_21 bS1_21 0 5.61629k
RF1_21 a1_21 s1_21 100k
CFRF1_21 a1_21 s1_21 2p
R1_21_0 nx0 s1_21 105k
R1_21_1 nx1 s1_21 267k
R1_21_2 x2 s1_21 147k
R1_21_3 nx3 s1_21 499k
R1_21_4 nx4 s1_21 732k
R1_21_5 x5 s1_21 649k
R1_21_6 x6 s1_21 196k
R1_21_7 nx7 s1_21 976k
R1_21_8 nx8 s1_21 178k
R1_21_9 nx9 s1_21 649k
R1_21_10 nx10 s1_21 634k
R1_21_11 x11 s1_21 453k
R1_21_12 nx12 s1_21 221k
R1_21_13 x13 s1_21 249k
R1_21_15 x15 s1_21 274k
R1_21_16 nx16 s1_21 4.02Meg
R1_21_17 nx17 s1_21 511k
R1_21_18 nx18 s1_21 576k
R1_21_19 nx19 s1_21 178k
R1_21_21 x21 s1_21 205k
R1_21_22 x22 s1_21 1.37Meg
R1_21_23 nx23 s1_21 309k
R1_21_24 nx24 s1_21 1.47Meg
R1_21_26 nx26 s1_21 2.15Meg
R1_21_27 x27 s1_21 392k
R1_21_29 nx29 s1_21 732k
R1_21_30 nx30 s1_21 2.43Meg
R1_21_31 x31 s1_21 287k
R1_21_32 x32 s1_21 196k
R1_21_33 x33 s1_21 261k
R1_21_34 x34 s1_21 1.91Meg
R1_21_35 x35 s1_21 590k
R1_21_36 nx36 s1_21 226k
R1_21_37 nx37 s1_21 665k
R1_21_38 nx38 s1_21 442k
R1_21_39 nx39 s1_21 348k
R1_21_40 x40 s1_21 165k
R1_21_41 x41 s1_21 280k
R1_21_42 x42 s1_21 475k
R1_21_43 nx43 s1_21 1.58Meg
R1_21_44 nx44 s1_21 453k
R1_21_45 x45 s1_21 1.02Meg
R1_21_46 x46 s1_21 2.37Meg
R1_21_47 nx47 s1_21 1.3Meg
R1_21_48 x48 s1_21 73.2k
R1_21_49 x49 s1_21 301k
R1_21_50 x50 s1_21 2.49Meg
R1_21_53 x53 s1_21 499k
R1_21_54 x54 s1_21 150k
R1_21_55 x55 s1_21 221k
R1_21_56 x56 s1_21 210k
R1_21_57 x57 s1_21 464k
R1_21_59 x59 s1_21 536k
R1_21_60 x60 s1_21 267k
R1_21_61 nx61 s1_21 1.07Meg
R1_21_62 nx62 s1_21 1.07Meg
R1_21_63 x63 s1_21 665k
RB1_21 bn s1_21 1Meg
XI1_21 bI1_21 si1_21 vcc vee na1_21 LT1810
RBALI1_21 bI1_21 0 50k
RIA1_21 a1_21 si1_21 100k
RIF1_21 na1_21 si1_21 100k
CFRIF1_21 na1_21 si1_21 2p
XS1_22 bS1_22 s1_22 vcc veer a1_22 LT1810
RBALS1_22 bS1_22 0 6.74929k
RF1_22 a1_22 s1_22 100k
CFRF1_22 a1_22 s1_22 2p
R1_22_0 x0 s1_22 243k
R1_22_1 nx1 s1_22 1.18Meg
R1_22_2 x2 s1_22 324k
R1_22_3 x3 s1_22 1.82Meg
R1_22_4 x4 s1_22 698k
R1_22_5 x5 s1_22 243k
R1_22_7 nx7 s1_22 768k
R1_22_8 nx8 s1_22 432k
R1_22_9 nx9 s1_22 280k
R1_22_11 x11 s1_22 340k
R1_22_13 x13 s1_22 475k
R1_22_14 x14 s1_22 475k
R1_22_15 x15 s1_22 422k
R1_22_16 nx16 s1_22 523k
R1_22_17 x17 s1_22 953k
R1_22_18 nx18 s1_22 1.58Meg
R1_22_19 nx19 s1_22 698k
R1_22_20 x20 s1_22 649k
R1_22_21 x21 s1_22 825k
R1_22_23 x23 s1_22 1.13Meg
R1_22_24 x24 s1_22 1.18Meg
R1_22_25 x25 s1_22 348k
R1_22_26 x26 s1_22 442k
R1_22_27 x27 s1_22 845k
R1_22_28 x28 s1_22 324k
R1_22_29 x29 s1_22 1.82Meg
R1_22_30 nx30 s1_22 2.37Meg
R1_22_31 nx31 s1_22 365k
R1_22_32 nx32 s1_22 294k
R1_22_33 nx33 s1_22 309k
R1_22_34 nx34 s1_22 412k
R1_22_35 nx35 s1_22 121k
R1_22_36 nx36 s1_22 226k
R1_22_37 nx37 s1_22 475k
R1_22_38 nx38 s1_22 453k
R1_22_39 nx39 s1_22 402k
R1_22_40 nx40 s1_22 453k
R1_22_41 nx41 s1_22 154k
R1_22_42 nx42 s1_22 523k
R1_22_44 nx44 s1_22 2.37Meg
R1_22_45 nx45 s1_22 1.4Meg
R1_22_46 nx46 s1_22 2.32Meg
R1_22_47 nx47 s1_22 487k
R1_22_48 x48 s1_22 143k
R1_22_49 x49 s1_22 182k
R1_22_50 x50 s1_22 316k
R1_22_51 x51 s1_22 931k
R1_22_52 x52 s1_22 619k
R1_22_53 x53 s1_22 1.07Meg
R1_22_54 x54 s1_22 536k
R1_22_55 x55 s1_22 1.5Meg
R1_22_56 nx56 s1_22 383k
R1_22_57 x57 s1_22 1.05Meg
R1_22_58 nx58 s1_22 604k
R1_22_59 x59 s1_22 274k
R1_22_60 x60 s1_22 1.05Meg
R1_22_61 x61 s1_22 665k
R1_22_62 x62 s1_22 576k
R1_22_63 x63 s1_22 215k
RB1_22 bn s1_22 422k
XI1_22 bI1_22 si1_22 vcc vee na1_22 LT1810
RBALI1_22 bI1_22 0 50k
RIA1_22 a1_22 si1_22 100k
RIF1_22 na1_22 si1_22 100k
CFRIF1_22 na1_22 si1_22 2p
XS1_23 bS1_23 s1_23 vcc veer a1_23 LT1810
RBALS1_23 bS1_23 0 5.45665k
RF1_23 a1_23 s1_23 100k
CFRF1_23 a1_23 s1_23 2p
R1_23_0 x0 s1_23 182k
R1_23_1 nx1 s1_23 154k
R1_23_2 nx2 s1_23 169k
R1_23_3 x3 s1_23 215k
R1_23_4 x4 s1_23 1.3Meg
R1_23_5 x5 s1_23 750k
R1_23_6 x6 s1_23 357k
R1_23_7 nx7 s1_23 511k
R1_23_8 nx8 s1_23 442k
R1_23_9 nx9 s1_23 133k
R1_23_10 nx10 s1_23 274k
R1_23_11 x11 s1_23 115k
R1_23_12 nx12 s1_23 475k
R1_23_13 nx13 s1_23 1.05Meg
R1_23_14 x14 s1_23 200k
R1_23_16 nx16 s1_23 953k
R1_23_17 nx17 s1_23 604k
R1_23_18 nx18 s1_23 294k
R1_23_19 x19 s1_23 150k
R1_23_20 nx20 s1_23 1.24Meg
R1_23_21 x21 s1_23 1.47Meg
R1_23_23 nx23 s1_23 124k
R1_23_24 x24 s1_23 1.15Meg
R1_23_25 nx25 s1_23 316k
R1_23_26 nx26 s1_23 301k
R1_23_27 x27 s1_23 215k
R1_23_28 x28 s1_23 732k
R1_23_29 nx29 s1_23 2.37Meg
R1_23_30 nx30 s1_23 576k
R1_23_31 nx31 s1_23 576k
R1_23_32 nx32 s1_23 845k
R1_23_33 nx33 s1_23 768k
R1_23_34 nx34 s1_23 442k
R1_23_35 x35 s1_23 1.69Meg
R1_23_36 x36 s1_23 1.5Meg
R1_23_37 x37 s1_23 280k
R1_23_38 x38 s1_23 681k
R1_23_39 nx39 s1_23 523k
R1_23_40 x40 s1_23 105k
R1_23_41 nx41 s1_23 1.91Meg
R1_23_42 x42 s1_23 562k
R1_23_43 nx43 s1_23 1.47Meg
R1_23_45 x45 s1_23 215k
R1_23_46 nx46 s1_23 1.1Meg
R1_23_47 nx47 s1_23 243k
R1_23_48 x48 s1_23 150k
R1_23_49 nx49 s1_23 715k
R1_23_50 x50 s1_23 549k
R1_23_51 nx51 s1_23 1.1Meg
R1_23_52 nx52 s1_23 1.1Meg
R1_23_53 nx53 s1_23 392k
R1_23_54 nx54 s1_23 1.87Meg
R1_23_55 nx55 s1_23 511k
R1_23_56 nx56 s1_23 150k
R1_23_57 x57 s1_23 348k
R1_23_58 x58 s1_23 536k
R1_23_60 nx60 s1_23 1.82Meg
R1_23_61 nx61 s1_23 205k
R1_23_63 nx63 s1_23 374k
RB1_23 bn s1_23 374k
XI1_23 bI1_23 si1_23 vcc vee na1_23 LT1810
RBALI1_23 bI1_23 0 50k
RIA1_23 a1_23 si1_23 100k
RIF1_23 na1_23 si1_23 100k
CFRIF1_23 na1_23 si1_23 2p
XS1_24 bS1_24 s1_24 vcc veer a1_24 LT1810
RBALS1_24 bS1_24 0 6.53348k
RF1_24 a1_24 s1_24 100k
CFRF1_24 a1_24 s1_24 2p
R1_24_0 x0 s1_24 232k
R1_24_1 nx1 s1_24 1.27Meg
R1_24_2 nx2 s1_24 909k
R1_24_3 nx3 s1_24 402k
R1_24_4 nx4 s1_24 1Meg
R1_24_6 x6 s1_24 1.54Meg
R1_24_7 x7 s1_24 422k
R1_24_8 x8 s1_24 487k
R1_24_10 nx10 s1_24 1.07Meg
R1_24_11 nx11 s1_24 536k
R1_24_12 nx12 s1_24 750k
R1_24_13 x13 s1_24 1.78Meg
R1_24_15 nx15 s1_24 422k
R1_24_16 x16 s1_24 787k
R1_24_17 x17 s1_24 2.05Meg
R1_24_18 nx18 s1_24 274k
R1_24_19 nx19 s1_24 196k
R1_24_20 x20 s1_24 301k
R1_24_21 x21 s1_24 590k
R1_24_22 x22 s1_24 953k
R1_24_23 nx23 s1_24 165k
R1_24_24 x24 s1_24 634k
R1_24_26 nx26 s1_24 453k
R1_24_27 nx27 s1_24 1.47Meg
R1_24_28 x28 s1_24 649k
R1_24_29 x29 s1_24 1.02Meg
R1_24_30 x30 s1_24 1.47Meg
R1_24_31 x31 s1_24 274k
R1_24_32 x32 s1_24 169k
R1_24_33 x33 s1_24 261k
R1_24_34 x34 s1_24 221k
R1_24_35 nx35 s1_24 237k
R1_24_37 x37 s1_24 392k
R1_24_38 x38 s1_24 196k
R1_24_39 nx39 s1_24 487k
R1_24_40 nx40 s1_24 191k
R1_24_43 x43 s1_24 665k
R1_24_44 x44 s1_24 309k
R1_24_45 x45 s1_24 280k
R1_24_46 x46 s1_24 1.47Meg
R1_24_47 nx47 s1_24 634k
R1_24_48 nx48 s1_24 169k
R1_24_49 nx49 s1_24 340k
R1_24_50 nx50 s1_24 301k
R1_24_51 nx51 s1_24 374k
R1_24_52 nx52 s1_24 301k
R1_24_53 nx53 s1_24 243k
R1_24_54 nx54 s1_24 196k
R1_24_55 nx55 s1_24 274k
R1_24_56 nx56 s1_24 1.4Meg
R1_24_57 x57 s1_24 3.16Meg
R1_24_58 nx58 s1_24 1.37Meg
R1_24_60 nx60 s1_24 267k
R1_24_61 nx61 s1_24 1.69Meg
R1_24_62 nx62 s1_24 1.1Meg
R1_24_63 nx63 s1_24 365k
RB1_24 bn s1_24 402k
XI1_24 bI1_24 si1_24 vcc vee na1_24 LT1810
RBALI1_24 bI1_24 0 50k
RIA1_24 a1_24 si1_24 100k
RIF1_24 na1_24 si1_24 100k
CFRIF1_24 na1_24 si1_24 2p
XS1_25 bS1_25 s1_25 vcc veer a1_25 LT1810
RBALS1_25 bS1_25 0 6.31866k
RF1_25 a1_25 s1_25 100k
CFRF1_25 a1_25 s1_25 2p
R1_25_0 nx0 s1_25 866k
R1_25_1 x1 s1_25 178k
R1_25_2 x2 s1_25 182k
R1_25_3 x3 s1_25 280k
R1_25_5 nx5 s1_25 1.74Meg
R1_25_6 nx6 s1_25 392k
R1_25_7 nx7 s1_25 562k
R1_25_8 nx8 s1_25 953k
R1_25_9 nx9 s1_25 178k
R1_25_10 x10 s1_25 158k
R1_25_11 x11 s1_25 215k
R1_25_12 x12 s1_25 1.15Meg
R1_25_13 nx13 s1_25 237k
R1_25_15 nx15 s1_25 1.27Meg
R1_25_17 nx17 s1_25 2.21Meg
R1_25_19 x19 s1_25 1.07Meg
R1_25_20 x20 s1_25 649k
R1_25_21 nx21 s1_25 287k
R1_25_22 nx22 s1_25 340k
R1_25_23 x23 s1_25 1.4Meg
R1_25_24 nx24 s1_25 562k
R1_25_25 nx25 s1_25 187k
R1_25_27 nx27 s1_25 1.69Meg
R1_25_28 x28 s1_25 301k
R1_25_29 nx29 s1_25 619k
R1_25_30 nx30 s1_25 140k
R1_25_31 nx31 s1_25 499k
R1_25_32 nx32 s1_25 221k
R1_25_33 nx33 s1_25 215k
R1_25_34 nx34 s1_25 1.62Meg
R1_25_35 x35 s1_25 487k
R1_25_36 x36 s1_25 196k
R1_25_37 nx37 s1_25 499k
R1_25_38 nx38 s1_25 1.07Meg
R1_25_39 nx39 s1_25 316k
R1_25_41 nx41 s1_25 1.37Meg
R1_25_42 nx42 s1_25 274k
R1_25_43 nx43 s1_25 422k
R1_25_44 x44 s1_25 374k
R1_25_46 x46 s1_25 576k
R1_25_47 x47 s1_25 619k
R1_25_48 x48 s1_25 442k
R1_25_49 x49 s1_25 887k
R1_25_51 x51 s1_25 536k
R1_25_52 x52 s1_25 499k
R1_25_54 x54 s1_25 2.1Meg
R1_25_55 nx55 s1_25 825k
R1_25_56 nx56 s1_25 383k
R1_25_57 nx57 s1_25 453k
R1_25_58 nx58 s1_25 392k
R1_25_59 x59 s1_25 232k
R1_25_60 nx60 s1_25 604k
R1_25_61 x61 s1_25 205k
R1_25_62 x62 s1_25 768k
R1_25_63 x63 s1_25 158k
RB1_25 bn s1_25 665k
XI1_25 bI1_25 si1_25 vcc vee na1_25 LT1810
RBALI1_25 bI1_25 0 50k
RIA1_25 a1_25 si1_25 100k
RIF1_25 na1_25 si1_25 100k
CFRIF1_25 na1_25 si1_25 2p
XS1_26 bS1_26 s1_26 vcc veer a1_26 LT1810
RBALS1_26 bS1_26 0 6.41537k
RF1_26 a1_26 s1_26 100k
CFRF1_26 a1_26 s1_26 2p
R1_26_0 x0 s1_26 267k
R1_26_1 x1 s1_26 243k
R1_26_2 x2 s1_26 205k
R1_26_3 x3 s1_26 866k
R1_26_4 x4 s1_26 221k
R1_26_5 x5 s1_26 200k
R1_26_6 x6 s1_26 1.27Meg
R1_26_7 nx7 s1_26 453k
R1_26_9 x9 s1_26 475k
R1_26_10 x10 s1_26 1.43Meg
R1_26_11 x11 s1_26 931k
R1_26_13 x13 s1_26 1.47Meg
R1_26_14 x14 s1_26 3.92Meg
R1_26_15 nx15 s1_26 1.87Meg
R1_26_16 x16 s1_26 1.18Meg
R1_26_18 nx18 s1_26 221k
R1_26_19 x19 s1_26 1.21Meg
R1_26_20 x20 s1_26 649k
R1_26_22 x22 s1_26 649k
R1_26_23 nx23 s1_26 215k
R1_26_24 x24 s1_26 590k
R1_26_25 nx25 s1_26 140k
R1_26_26 nx26 s1_26 113k
R1_26_27 nx27 s1_26 287k
R1_26_28 x28 s1_26 953k
R1_26_29 x29 s1_26 1.18Meg
R1_26_30 x30 s1_26 453k
R1_26_31 x31 s1_26 887k
R1_26_32 x32 s1_26 1.18Meg
R1_26_33 x33 s1_26 301k
R1_26_34 nx34 s1_26 301k
R1_26_35 nx35 s1_26 402k
R1_26_36 x36 s1_26 3.09Meg
R1_26_37 nx37 s1_26 562k
R1_26_38 x38 s1_26 301k
R1_26_40 x40 s1_26 332k
R1_26_41 x41 s1_26 549k
R1_26_42 x42 s1_26 931k
R1_26_44 nx44 s1_26 1.15Meg
R1_26_45 x45 s1_26 649k
R1_26_46 x46 s1_26 768k
R1_26_47 x47 s1_26 287k
R1_26_48 x48 s1_26 226k
R1_26_49 x49 s1_26 536k
R1_26_50 nx50 s1_26 1.02Meg
R1_26_51 x51 s1_26 732k
R1_26_52 x52 s1_26 287k
R1_26_53 x53 s1_26 1.54Meg
R1_26_54 nx54 s1_26 562k
R1_26_55 nx55 s1_26 316k
R1_26_56 nx56 s1_26 187k
R1_26_59 x59 s1_26 274k
R1_26_60 nx60 s1_26 383k
R1_26_61 nx61 s1_26 523k
R1_26_62 nx62 s1_26 110k
R1_26_63 nx63 s1_26 316k
RB1_26 bn s1_26 562k
XI1_26 bI1_26 si1_26 vcc vee na1_26 LT1810
RBALI1_26 bI1_26 0 50k
RIA1_26 a1_26 si1_26 100k
RIF1_26 na1_26 si1_26 100k
CFRIF1_26 na1_26 si1_26 2p
XS1_27 bS1_27 s1_27 vcc veer a1_27 LT1810
RBALS1_27 bS1_27 0 5.63494k
RF1_27 a1_27 s1_27 100k
CFRF1_27 a1_27 s1_27 2p
R1_27_0 x0 s1_27 909k
R1_27_1 nx1 s1_27 453k
R1_27_3 x3 s1_27 806k
R1_27_4 x4 s1_27 110k
R1_27_5 nx5 s1_27 1.13Meg
R1_27_8 nx8 s1_27 787k
R1_27_9 nx9 s1_27 357k
R1_27_10 x10 s1_27 158k
R1_27_11 x11 s1_27 140k
R1_27_12 nx12 s1_27 649k
R1_27_13 nx13 s1_27 3.48Meg
R1_27_14 x14 s1_27 1.69Meg
R1_27_15 nx15 s1_27 187k
R1_27_16 nx16 s1_27 511k
R1_27_17 nx17 s1_27 178k
R1_27_18 x18 s1_27 137k
R1_27_19 x19 s1_27 511k
R1_27_20 nx20 s1_27 196k
R1_27_22 x22 s1_27 931k
R1_27_23 x23 s1_27 280k
R1_27_24 nx24 s1_27 787k
R1_27_25 x25 s1_27 787k
R1_27_26 x26 s1_27 523k
R1_27_28 x28 s1_27 464k
R1_27_29 x29 s1_27 154k
R1_27_30 x30 s1_27 383k
R1_27_31 x31 s1_27 127k
R1_27_32 x32 s1_27 374k
R1_27_33 nx33 s1_27 549k
R1_27_34 nx34 s1_27 665k
R1_27_35 nx35 s1_27 324k
R1_27_36 nx36 s1_27 1.13Meg
R1_27_37 x37 s1_27 698k
R1_27_38 x38 s1_27 255k
R1_27_39 nx39 s1_27 154k
R1_27_40 nx40 s1_27 200k
R1_27_41 nx41 s1_27 357k
R1_27_42 nx42 s1_27 348k
R1_27_43 x43 s1_27 2Meg
R1_27_45 nx45 s1_27 383k
R1_27_46 nx46 s1_27 2.8Meg
R1_27_47 x47 s1_27 887k
R1_27_49 x49 s1_27 1.43Meg
R1_27_50 x50 s1_27 1.47Meg
R1_27_51 x51 s1_27 1.87Meg
R1_27_52 x52 s1_27 909k
R1_27_53 nx53 s1_27 475k
R1_27_54 nx54 s1_27 274k
R1_27_55 nx55 s1_27 165k
R1_27_56 nx56 s1_27 191k
R1_27_57 x57 s1_27 698k
R1_27_59 x59 s1_27 237k
R1_27_60 x60 s1_27 475k
R1_27_61 x61 s1_27 562k
R1_27_62 nx62 s1_27 215k
R1_27_63 nx63 s1_27 249k
RB1_27 bn s1_27 475k
XI1_27 bI1_27 si1_27 vcc vee na1_27 LT1810
RBALI1_27 bI1_27 0 50k
RIA1_27 a1_27 si1_27 100k
RIF1_27 na1_27 si1_27 100k
CFRIF1_27 na1_27 si1_27 2p
XS1_28 bS1_28 s1_28 vcc veer a1_28 LT1810
RBALS1_28 bS1_28 0 4.74998k
RF1_28 a1_28 s1_28 100k
CFRF1_28 a1_28 s1_28 2p
R1_28_0 x0 s1_28 140k
R1_28_1 nx1 s1_28 825k
R1_28_2 nx2 s1_28 178k
R1_28_3 nx3 s1_28 511k
R1_28_4 nx4 s1_28 392k
R1_28_5 x5 s1_28 237k
R1_28_6 x6 s1_28 267k
R1_28_7 nx7 s1_28 165k
R1_28_8 x8 s1_28 523k
R1_28_9 x9 s1_28 866k
R1_28_10 nx10 s1_28 357k
R1_28_11 nx11 s1_28 261k
R1_28_12 x12 s1_28 487k
R1_28_13 x13 s1_28 732k
R1_28_14 x14 s1_28 511k
R1_28_15 nx15 s1_28 178k
R1_28_16 x16 s1_28 169k
R1_28_18 nx18 s1_28 750k
R1_28_19 x19 s1_28 681k
R1_28_20 x20 s1_28 221k
R1_28_21 nx21 s1_28 887k
R1_28_23 x23 s1_28 287k
R1_28_24 x24 s1_28 105k
R1_28_25 x25 s1_28 309k
R1_28_26 nx26 s1_28 324k
R1_28_27 x27 s1_28 340k
R1_28_28 nx28 s1_28 348k
R1_28_29 nx29 s1_28 2.94Meg
R1_28_30 nx30 s1_28 649k
R1_28_31 nx31 s1_28 1.62Meg
R1_28_32 x32 s1_28 274k
R1_28_34 nx34 s1_28 909k
R1_28_36 nx36 s1_28 287k
R1_28_37 nx37 s1_28 536k
R1_28_38 nx38 s1_28 422k
R1_28_39 nx39 s1_28 1.58Meg
R1_28_41 nx41 s1_28 523k
R1_28_42 x42 s1_28 909k
R1_28_43 nx43 s1_28 243k
R1_28_44 nx44 s1_28 511k
R1_28_45 x45 s1_28 1.4Meg
R1_28_46 x46 s1_28 1.5Meg
R1_28_47 nx47 s1_28 182k
R1_28_48 x48 s1_28 154k
R1_28_49 x49 s1_28 113k
R1_28_50 x50 s1_28 909k
R1_28_51 x51 s1_28 1.87Meg
R1_28_52 x52 s1_28 237k
R1_28_53 x53 s1_28 487k
R1_28_54 x54 s1_28 232k
R1_28_55 nx55 s1_28 1.69Meg
R1_28_56 x56 s1_28 191k
R1_28_57 x57 s1_28 348k
R1_28_58 x58 s1_28 165k
R1_28_59 x59 s1_28 316k
R1_28_60 x60 s1_28 237k
R1_28_61 x61 s1_28 133k
R1_28_62 x62 s1_28 124k
R1_28_63 x63 s1_28 127k
RB1_28 bn s1_28 324k
XI1_28 bI1_28 si1_28 vcc vee na1_28 LT1810
RBALI1_28 bI1_28 0 50k
RIA1_28 a1_28 si1_28 100k
RIF1_28 na1_28 si1_28 100k
CFRIF1_28 na1_28 si1_28 2p
XS1_29 bS1_29 s1_29 vcc veer a1_29 LT1810
RBALS1_29 bS1_29 0 5.0364k
RF1_29 a1_29 s1_29 100k
CFRF1_29 a1_29 s1_29 2p
R1_29_0 x0 s1_29 124k
R1_29_1 x1 s1_29 348k
R1_29_2 nx2 s1_29 97.6k
R1_29_3 nx3 s1_29 392k
R1_29_4 x4 s1_29 2Meg
R1_29_5 x5 s1_29 178k
R1_29_6 x6 s1_29 453k
R1_29_7 x7 s1_29 267k
R1_29_8 x8 s1_29 97.6k
R1_29_9 x9 s1_29 174k
R1_29_10 x10 s1_29 200k
R1_29_11 x11 s1_29 365k
R1_29_12 x12 s1_29 1.65Meg
R1_29_13 nx13 s1_29 475k
R1_29_14 x14 s1_29 604k
R1_29_15 nx15 s1_29 4.12Meg
R1_29_16 x16 s1_29 267k
R1_29_17 x17 s1_29 169k
R1_29_19 nx19 s1_29 866k
R1_29_20 x20 s1_29 2.21Meg
R1_29_21 x21 s1_29 866k
R1_29_22 nx22 s1_29 523k
R1_29_23 nx23 s1_29 768k
R1_29_24 x24 s1_29 549k
R1_29_26 nx26 s1_29 340k
R1_29_27 x27 s1_29 243k
R1_29_28 x28 s1_29 294k
R1_29_29 nx29 s1_29 178k
R1_29_30 nx30 s1_29 191k
R1_29_31 x31 s1_29 1.58Meg
R1_29_32 nx32 s1_29 221k
R1_29_33 nx33 s1_29 1.78Meg
R1_29_34 nx34 s1_29 562k
R1_29_35 nx35 s1_29 294k
R1_29_36 nx36 s1_29 1.37Meg
R1_29_37 nx37 s1_29 294k
R1_29_38 x38 s1_29 715k
R1_29_39 x39 s1_29 178k
R1_29_40 x40 s1_29 205k
R1_29_41 nx41 s1_29 280k
R1_29_42 nx42 s1_29 309k
R1_29_43 x43 s1_29 590k
R1_29_45 x45 s1_29 274k
R1_29_46 x46 s1_29 665k
R1_29_47 nx47 s1_29 187k
R1_29_48 nx48 s1_29 442k
R1_29_49 nx49 s1_29 187k
R1_29_50 x50 s1_29 392k
R1_29_51 x51 s1_29 374k
R1_29_52 x52 s1_29 2.21Meg
R1_29_53 x53 s1_29 1.27Meg
R1_29_54 nx54 s1_29 221k
R1_29_55 nx55 s1_29 348k
R1_29_56 x56 s1_29 274k
R1_29_57 nx57 s1_29 1.21Meg
R1_29_58 nx58 s1_29 523k
R1_29_59 nx59 s1_29 412k
R1_29_60 x60 s1_29 332k
R1_29_61 nx61 s1_29 1.21Meg
R1_29_62 nx62 s1_29 301k
R1_29_63 x63 s1_29 665k
RB1_29 bp s1_29 1.33Meg
XI1_29 bI1_29 si1_29 vcc vee na1_29 LT1810
RBALI1_29 bI1_29 0 50k
RIA1_29 a1_29 si1_29 100k
RIF1_29 na1_29 si1_29 100k
CFRIF1_29 na1_29 si1_29 2p
XS1_30 bS1_30 s1_30 vcc veer a1_30 LT1810
RBALS1_30 bS1_30 0 5.54422k
RF1_30 a1_30 s1_30 100k
CFRF1_30 a1_30 s1_30 2p
R1_30_2 nx2 s1_30 402k
R1_30_3 nx3 s1_30 487k
R1_30_6 nx6 s1_30 590k
R1_30_7 nx7 s1_30 237k
R1_30_8 nx8 s1_30 412k
R1_30_9 nx9 s1_30 464k
R1_30_10 x10 s1_30 511k
R1_30_11 nx11 s1_30 2Meg
R1_30_12 nx12 s1_30 1Meg
R1_30_13 nx13 s1_30 2Meg
R1_30_14 nx14 s1_30 453k
R1_30_15 nx15 s1_30 340k
R1_30_16 nx16 s1_30 162k
R1_30_17 x17 s1_30 787k
R1_30_19 nx19 s1_30 845k
R1_30_20 x20 s1_30 432k
R1_30_23 x23 s1_30 274k
R1_30_24 x24 s1_30 187k
R1_30_25 x25 s1_30 137k
R1_30_26 x26 s1_30 210k
R1_30_27 nx27 s1_30 158k
R1_30_28 nx28 s1_30 365k
R1_30_30 x30 s1_30 825k
R1_30_31 x31 s1_30 576k
R1_30_32 nx32 s1_30 402k
R1_30_33 x33 s1_30 169k
R1_30_34 x34 s1_30 80.6k
R1_30_35 x35 s1_30 130k
R1_30_36 nx36 s1_30 1.78Meg
R1_30_37 nx37 s1_30 866k
R1_30_38 nx38 s1_30 287k
R1_30_39 nx39 s1_30 1.33Meg
R1_30_40 nx40 s1_30 226k
R1_30_41 nx41 s1_30 140k
R1_30_42 nx42 s1_30 249k
R1_30_43 x43 s1_30 715k
R1_30_44 x44 s1_30 619k
R1_30_45 x45 s1_30 1.47Meg
R1_30_46 x46 s1_30 787k
R1_30_47 nx47 s1_30 365k
R1_30_48 x48 s1_30 124k
R1_30_49 x49 s1_30 301k
R1_30_50 nx50 s1_30 511k
R1_30_51 nx51 s1_30 324k
R1_30_52 x52 s1_30 348k
R1_30_53 nx53 s1_30 619k
R1_30_54 x54 s1_30 590k
R1_30_55 nx55 s1_30 750k
R1_30_58 x58 s1_30 324k
R1_30_59 x59 s1_30 324k
R1_30_60 nx60 s1_30 2.32Meg
R1_30_61 x61 s1_30 634k
R1_30_62 x62 s1_30 113k
R1_30_63 nx63 s1_30 287k
XI1_30 bI1_30 si1_30 vcc vee na1_30 LT1810
RBALI1_30 bI1_30 0 50k
RIA1_30 a1_30 si1_30 100k
RIF1_30 na1_30 si1_30 100k
CFRIF1_30 na1_30 si1_30 2p
XS1_31 bS1_31 s1_31 vcc veer a1_31 LT1810
RBALS1_31 bS1_31 0 5.4166k
RF1_31 a1_31 s1_31 100k
CFRF1_31 a1_31 s1_31 2p
R1_31_0 x0 s1_31 127k
R1_31_1 x1 s1_31 348k
R1_31_2 x2 s1_31 332k
R1_31_3 x3 s1_31 196k
R1_31_4 x4 s1_31 768k
R1_31_5 x5 s1_31 590k
R1_31_6 nx6 s1_31 365k
R1_31_7 nx7 s1_31 205k
R1_31_9 nx9 s1_31 274k
R1_31_10 x10 s1_31 649k
R1_31_11 x11 s1_31 226k
R1_31_12 nx12 s1_31 1.54Meg
R1_31_13 nx13 s1_31 549k
R1_31_14 nx14 s1_31 453k
R1_31_15 nx15 s1_31 681k
R1_31_16 x16 s1_31 309k
R1_31_18 nx18 s1_31 649k
R1_31_19 nx19 s1_31 499k
R1_31_20 x20 s1_31 442k
R1_31_21 nx21 s1_31 536k
R1_31_22 nx22 s1_31 196k
R1_31_23 x23 s1_31 210k
R1_31_24 nx24 s1_31 2.1Meg
R1_31_26 x26 s1_31 475k
R1_31_27 x27 s1_31 182k
R1_31_28 x28 s1_31 178k
R1_31_31 x31 s1_31 205k
R1_31_33 x33 s1_31 1.27Meg
R1_31_34 x34 s1_31 196k
R1_31_35 x35 s1_31 205k
R1_31_36 x36 s1_31 2.1Meg
R1_31_39 x39 s1_31 130k
R1_31_40 nx40 s1_31 196k
R1_31_41 nx41 s1_31 523k
R1_31_42 nx42 s1_31 365k
R1_31_43 nx43 s1_31 768k
R1_31_44 nx44 s1_31 178k
R1_31_45 nx45 s1_31 162k
R1_31_47 x47 s1_31 604k
R1_31_48 nx48 s1_31 1.21Meg
R1_31_49 nx49 s1_31 348k
R1_31_51 x51 s1_31 316k
R1_31_52 x52 s1_31 1.96Meg
R1_31_53 nx53 s1_31 267k
R1_31_54 nx54 s1_31 732k
R1_31_55 nx55 s1_31 137k
R1_31_56 x56 s1_31 154k
R1_31_57 x57 s1_31 274k
R1_31_58 x58 s1_31 249k
R1_31_59 x59 s1_31 453k
R1_31_60 x60 s1_31 383k
R1_31_61 x61 s1_31 523k
R1_31_62 nx62 s1_31 392k
R1_31_63 nx63 s1_31 665k
RB1_31 bn s1_31 536k
XI1_31 bI1_31 si1_31 vcc vee na1_31 LT1810
RBALI1_31 bI1_31 0 50k
RIA1_31 a1_31 si1_31 100k
RIF1_31 na1_31 si1_31 100k
CFRIF1_31 na1_31 si1_31 2p
XS1_32 bS1_32 s1_32 vcc veer a1_32 LT1810
RBALS1_32 bS1_32 0 5.34143k
RF1_32 a1_32 s1_32 100k
CFRF1_32 a1_32 s1_32 2p
R1_32_0 nx0 s1_32 324k
R1_32_1 x1 s1_32 261k
R1_32_2 nx2 s1_32 340k
R1_32_4 nx4 s1_32 806k
R1_32_5 nx5 s1_32 1.05Meg
R1_32_6 nx6 s1_32 768k
R1_32_7 x7 s1_32 681k
R1_32_8 x8 s1_32 374k
R1_32_9 x9 s1_32 787k
R1_32_10 x10 s1_32 332k
R1_32_11 x11 s1_32 619k
R1_32_12 nx12 s1_32 1.4Meg
R1_32_13 nx13 s1_32 1.96Meg
R1_32_14 x14 s1_32 1.21Meg
R1_32_15 x15 s1_32 133k
R1_32_16 x16 s1_32 127k
R1_32_17 x17 s1_32 1Meg
R1_32_18 x18 s1_32 1.24Meg
R1_32_19 x19 s1_32 887k
R1_32_20 nx20 s1_32 340k
R1_32_21 nx21 s1_32 1.21Meg
R1_32_22 x22 s1_32 232k
R1_32_23 x23 s1_32 107k
R1_32_24 x24 s1_32 210k
R1_32_25 nx25 s1_32 475k
R1_32_26 nx26 s1_32 453k
R1_32_27 nx27 s1_32 280k
R1_32_28 nx28 s1_32 261k
R1_32_29 nx29 s1_32 787k
R1_32_30 x30 s1_32 174k
R1_32_31 x31 s1_32 71.5k
R1_32_32 nx32 s1_32 768k
R1_32_33 x33 s1_32 348k
R1_32_35 nx35 s1_32 392k
R1_32_36 x36 s1_32 2Meg
R1_32_37 x37 s1_32 210k
R1_32_38 x38 s1_32 182k
R1_32_39 x39 s1_32 750k
R1_32_40 x40 s1_32 205k
R1_32_41 x41 s1_32 374k
R1_32_42 nx42 s1_32 182k
R1_32_44 x44 s1_32 261k
R1_32_46 nx46 s1_32 237k
R1_32_47 nx47 s1_32 182k
R1_32_48 x48 s1_32 3.09Meg
R1_32_49 x49 s1_32 1.69Meg
R1_32_50 nx50 s1_32 1.58Meg
R1_32_51 x51 s1_32 1.78Meg
R1_32_52 x52 s1_32 348k
R1_32_53 x53 s1_32 309k
R1_32_55 x55 s1_32 237k
R1_32_56 nx56 s1_32 243k
R1_32_57 x57 s1_32 634k
R1_32_58 x58 s1_32 432k
R1_32_59 nx59 s1_32 464k
R1_32_60 x60 s1_32 887k
R1_32_61 nx61 s1_32 698k
R1_32_62 x62 s1_32 619k
R1_32_63 x63 s1_32 174k
RB1_32 bn s1_32 1.65Meg
XI1_32 bI1_32 si1_32 vcc vee na1_32 LT1810
RBALI1_32 bI1_32 0 50k
RIA1_32 a1_32 si1_32 100k
RIF1_32 na1_32 si1_32 100k
CFRIF1_32 na1_32 si1_32 2p
XS1_33 bS1_33 s1_33 vcc veer a1_33 LT1810
RBALS1_33 bS1_33 0 6.10966k
RF1_33 a1_33 s1_33 100k
CFRF1_33 a1_33 s1_33 2p
R1_33_0 nx0 s1_33 787k
R1_33_1 nx1 s1_33 267k
R1_33_2 nx2 s1_33 154k
R1_33_3 nx3 s1_33 3.4Meg
R1_33_4 nx4 s1_33 365k
R1_33_6 x6 s1_33 649k
R1_33_7 nx7 s1_33 169k
R1_33_8 x8 s1_33 787k
R1_33_9 nx9 s1_33 604k
R1_33_10 nx10 s1_33 243k
R1_33_11 x11 s1_33 1.13Meg
R1_33_13 x13 s1_33 249k
R1_33_14 nx14 s1_33 3.92Meg
R1_33_15 x15 s1_33 953k
R1_33_16 x16 s1_33 499k
R1_33_17 x17 s1_33 215k
R1_33_18 x18 s1_33 267k
R1_33_19 nx19 s1_33 154k
R1_33_20 nx20 s1_33 1.91Meg
R1_33_22 nx22 s1_33 1.96Meg
R1_33_23 x23 s1_33 100k
R1_33_24 nx24 s1_33 649k
R1_33_25 x25 s1_33 365k
R1_33_26 x26 s1_33 1.24Meg
R1_33_27 nx27 s1_33 1.4Meg
R1_33_28 x28 s1_33 374k
R1_33_29 x29 s1_33 442k
R1_33_30 x30 s1_33 280k
R1_33_32 nx32 s1_33 4.64Meg
R1_33_34 x34 s1_33 698k
R1_33_35 x35 s1_33 301k
R1_33_36 x36 s1_33 102k
R1_33_37 x37 s1_33 178k
R1_33_38 nx38 s1_33 604k
R1_33_39 nx39 s1_33 237k
R1_33_40 nx40 s1_33 340k
R1_33_41 nx41 s1_33 1.27Meg
R1_33_43 nx43 s1_33 332k
R1_33_44 x44 s1_33 7.68Meg
R1_33_45 nx45 s1_33 665k
R1_33_46 nx46 s1_33 392k
R1_33_47 nx47 s1_33 562k
R1_33_48 x48 s1_33 210k
R1_33_49 nx49 s1_33 383k
R1_33_50 nx50 s1_33 324k
R1_33_51 x51 s1_33 511k
R1_33_52 nx52 s1_33 523k
R1_33_53 nx53 s1_33 442k
R1_33_54 x54 s1_33 174k
R1_33_55 x55 s1_33 866k
R1_33_57 x57 s1_33 383k
R1_33_58 x58 s1_33 475k
R1_33_59 x59 s1_33 562k
R1_33_60 x60 s1_33 953k
R1_33_61 x61 s1_33 976k
R1_33_62 x62 s1_33 931k
R1_33_63 x63 s1_33 280k
RB1_33 bp s1_33 1.96Meg
XI1_33 bI1_33 si1_33 vcc vee na1_33 LT1810
RBALI1_33 bI1_33 0 50k
RIA1_33 a1_33 si1_33 100k
RIF1_33 na1_33 si1_33 100k
CFRIF1_33 na1_33 si1_33 2p
XS1_34 bS1_34 s1_34 vcc veer a1_34 LT1810
RBALS1_34 bS1_34 0 5.98554k
RF1_34 a1_34 s1_34 100k
CFRF1_34 a1_34 s1_34 2p
R1_34_0 x0 s1_34 140k
R1_34_1 x1 s1_34 133k
R1_34_2 x2 s1_34 976k
R1_34_3 nx3 s1_34 562k
R1_34_4 nx4 s1_34 261k
R1_34_6 nx6 s1_34 634k
R1_34_7 x7 s1_34 187k
R1_34_9 x9 s1_34 261k
R1_34_10 x10 s1_34 1.13Meg
R1_34_11 x11 s1_34 348k
R1_34_12 nx12 s1_34 340k
R1_34_13 nx13 s1_34 806k
R1_34_14 nx14 s1_34 392k
R1_34_15 nx15 s1_34 210k
R1_34_16 nx16 s1_34 1.33Meg
R1_34_17 x17 s1_34 619k
R1_34_18 nx18 s1_34 340k
R1_34_19 nx19 s1_34 464k
R1_34_20 nx20 s1_34 576k
R1_34_21 x21 s1_34 787k
R1_34_22 nx22 s1_34 383k
R1_34_24 x24 s1_34 562k
R1_34_25 x25 s1_34 1.3Meg
R1_34_26 x26 s1_34 1.91Meg
R1_34_27 x27 s1_34 432k
R1_34_28 x28 s1_34 249k
R1_34_29 x29 s1_34 681k
R1_34_30 x30 s1_34 232k
R1_34_31 nx31 s1_34 1Meg
R1_34_32 x32 s1_34 1.07Meg
R1_34_33 x33 s1_34 681k
R1_34_34 nx34 s1_34 294k
R1_34_35 x35 s1_34 536k
R1_34_36 x36 s1_34 237k
R1_34_37 x37 s1_34 1.13Meg
R1_34_38 nx38 s1_34 604k
R1_34_39 nx39 s1_34 1.54Meg
R1_34_40 nx40 s1_34 301k
R1_34_41 nx41 s1_34 619k
R1_34_42 nx42 s1_34 205k
R1_34_43 x43 s1_34 499k
R1_34_44 nx44 s1_34 392k
R1_34_45 nx45 s1_34 280k
R1_34_46 nx46 s1_34 255k
R1_34_47 nx47 s1_34 274k
R1_34_48 nx48 s1_34 332k
R1_34_49 nx49 s1_34 1Meg
R1_34_50 nx50 s1_34 2.05Meg
R1_34_51 nx51 s1_34 348k
R1_34_52 x52 s1_34 2.43Meg
R1_34_53 nx53 s1_34 523k
R1_34_54 nx54 s1_34 562k
R1_34_55 x55 s1_34 162k
R1_34_56 x56 s1_34 324k
R1_34_58 nx58 s1_34 475k
R1_34_59 x59 s1_34 294k
R1_34_60 nx60 s1_34 2.67Meg
R1_34_61 x61 s1_34 634k
R1_34_62 x62 s1_34 127k
R1_34_63 x63 s1_34 332k
RB1_34 bn s1_34 1.21Meg
XI1_34 bI1_34 si1_34 vcc vee na1_34 LT1810
RBALI1_34 bI1_34 0 50k
RIA1_34 a1_34 si1_34 100k
RIF1_34 na1_34 si1_34 100k
CFRIF1_34 na1_34 si1_34 2p
XS1_35 bS1_35 s1_35 vcc veer a1_35 LT1810
RBALS1_35 bS1_35 0 5.47288k
RF1_35 a1_35 s1_35 100k
CFRF1_35 a1_35 s1_35 2p
R1_35_0 nx0 s1_35 137k
R1_35_3 nx3 s1_35 127k
R1_35_4 nx4 s1_35 178k
R1_35_5 nx5 s1_35 274k
R1_35_6 x6 s1_35 511k
R1_35_7 x7 s1_35 150k
R1_35_9 nx9 s1_35 267k
R1_35_10 nx10 s1_35 536k
R1_35_11 nx11 s1_35 267k
R1_35_12 nx12 s1_35 1.27Meg
R1_35_13 nx13 s1_35 750k
R1_35_14 nx14 s1_35 953k
R1_35_15 x15 s1_35 113k
R1_35_17 x17 s1_35 121k
R1_35_18 x18 s1_35 88.7k
R1_35_19 x19 s1_35 169k
R1_35_20 nx20 s1_35 332k
R1_35_21 nx21 s1_35 806k
R1_35_23 nx23 s1_35 2.15Meg
R1_35_27 nx27 s1_35 1.27Meg
R1_35_28 nx28 s1_35 402k
R1_35_29 nx29 s1_35 562k
R1_35_30 nx30 s1_35 931k
R1_35_32 nx32 s1_35 232k
R1_35_33 nx33 s1_35 340k
R1_35_34 nx34 s1_35 1.05Meg
R1_35_35 x35 s1_35 604k
R1_35_36 x36 s1_35 174k
R1_35_37 x37 s1_35 412k
R1_35_38 x38 s1_35 1.37Meg
R1_35_39 x39 s1_35 392k
R1_35_40 nx40 s1_35 237k
R1_35_41 nx41 s1_35 1.02Meg
R1_35_42 nx42 s1_35 374k
R1_35_43 x43 s1_35 332k
R1_35_44 nx44 s1_35 4.87Meg
R1_35_46 x46 s1_35 825k
R1_35_47 x47 s1_35 127k
R1_35_48 x48 s1_35 402k
R1_35_49 nx49 s1_35 332k
R1_35_50 nx50 s1_35 1.47Meg
R1_35_51 x51 s1_35 1.91Meg
R1_35_52 x52 s1_35 2.61Meg
R1_35_53 nx53 s1_35 845k
R1_35_54 x54 s1_35 1.24Meg
R1_35_55 x55 s1_35 287k
R1_35_56 x56 s1_35 698k
R1_35_57 x57 s1_35 1.21Meg
R1_35_58 nx58 s1_35 182k
R1_35_59 nx59 s1_35 374k
R1_35_60 nx60 s1_35 2.21Meg
R1_35_61 x61 s1_35 357k
R1_35_62 nx62 s1_35 374k
R1_35_63 x63 s1_35 115k
RB1_35 bn s1_35 348k
XI1_35 bI1_35 si1_35 vcc vee na1_35 LT1810
RBALI1_35 bI1_35 0 50k
RIA1_35 a1_35 si1_35 100k
RIF1_35 na1_35 si1_35 100k
CFRIF1_35 na1_35 si1_35 2p
XS1_36 bS1_36 s1_36 vcc veer a1_36 LT1810
RBALS1_36 bS1_36 0 5.98463k
RF1_36 a1_36 s1_36 100k
CFRF1_36 a1_36 s1_36 2p
R1_36_0 x0 s1_36 442k
R1_36_1 nx1 s1_36 1.33Meg
R1_36_2 nx2 s1_36 127k
R1_36_3 x3 s1_36 340k
R1_36_4 x4 s1_36 130k
R1_36_5 x5 s1_36 294k
R1_36_6 nx6 s1_36 383k
R1_36_8 nx8 s1_36 487k
R1_36_9 nx9 s1_36 475k
R1_36_10 nx10 s1_36 182k
R1_36_11 nx11 s1_36 511k
R1_36_12 x12 s1_36 130k
R1_36_13 x13 s1_36 1.24Meg
R1_36_14 nx14 s1_36 340k
R1_36_15 nx15 s1_36 215k
R1_36_16 x16 s1_36 931k
R1_36_17 x17 s1_36 261k
R1_36_18 nx18 s1_36 442k
R1_36_19 nx19 s1_36 243k
R1_36_20 x20 s1_36 143k
R1_36_21 nx21 s1_36 316k
R1_36_22 nx22 s1_36 523k
R1_36_23 nx23 s1_36 732k
R1_36_24 nx24 s1_36 523k
R1_36_25 nx25 s1_36 1.1Meg
R1_36_26 nx26 s1_36 511k
R1_36_27 x27 s1_36 590k
R1_36_28 x28 s1_36 1.05Meg
R1_36_29 nx29 s1_36 562k
R1_36_30 nx30 s1_36 887k
R1_36_31 x31 s1_36 243k
R1_36_32 x32 s1_36 383k
R1_36_33 x33 s1_36 634k
R1_36_34 x34 s1_36 931k
R1_36_35 x35 s1_36 787k
R1_36_36 nx36 s1_36 402k
R1_36_37 nx37 s1_36 576k
R1_36_39 nx39 s1_36 619k
R1_36_40 x40 s1_36 267k
R1_36_41 x41 s1_36 487k
R1_36_42 nx42 s1_36 1.21Meg
R1_36_44 x44 s1_36 715k
R1_36_45 nx45 s1_36 1.54Meg
R1_36_46 x46 s1_36 348k
R1_36_47 x47 s1_36 634k
R1_36_48 x48 s1_36 432k
R1_36_50 nx50 s1_36 549k
R1_36_51 nx51 s1_36 392k
R1_36_52 x52 s1_36 340k
R1_36_53 x53 s1_36 1.3Meg
R1_36_54 nx54 s1_36 1.18Meg
R1_36_55 x55 s1_36 768k
R1_36_56 nx56 s1_36 2.37Meg
R1_36_57 nx57 s1_36 274k
R1_36_58 nx58 s1_36 316k
R1_36_60 x60 s1_36 1.24Meg
R1_36_61 x61 s1_36 143k
R1_36_62 x62 s1_36 243k
R1_36_63 x63 s1_36 226k
RB1_36 bp s1_36 931k
XI1_36 bI1_36 si1_36 vcc vee na1_36 LT1810
RBALI1_36 bI1_36 0 50k
RIA1_36 a1_36 si1_36 100k
RIF1_36 na1_36 si1_36 100k
CFRIF1_36 na1_36 si1_36 2p
XS1_37 bS1_37 s1_37 vcc veer a1_37 LT1810
RBALS1_37 bS1_37 0 5.12833k
RF1_37 a1_37 s1_37 100k
CFRF1_37 a1_37 s1_37 2p
R1_37_0 nx0 s1_37 174k
R1_37_1 x1 s1_37 866k
R1_37_2 nx2 s1_37 169k
R1_37_3 nx3 s1_37 442k
R1_37_4 x4 s1_37 232k
R1_37_5 x5 s1_37 205k
R1_37_6 x6 s1_37 619k
R1_37_7 nx7 s1_37 357k
R1_37_8 nx8 s1_37 124k
R1_37_9 nx9 s1_37 523k
R1_37_10 x10 s1_37 1.43Meg
R1_37_11 nx11 s1_37 732k
R1_37_12 nx12 s1_37 432k
R1_37_13 x13 s1_37 255k
R1_37_14 x14 s1_37 102k
R1_37_15 x15 s1_37 162k
R1_37_16 nx16 s1_37 215k
R1_37_17 x17 s1_37 604k
R1_37_18 x18 s1_37 226k
R1_37_19 nx19 s1_37 357k
R1_37_20 nx20 s1_37 196k
R1_37_21 x21 s1_37 226k
R1_37_22 x22 s1_37 66.5k
R1_37_23 x23 s1_37 499k
R1_37_24 nx24 s1_37 8.87Meg
R1_37_25 x25 s1_37 191k
R1_37_26 nx26 s1_37 316k
R1_37_27 nx27 s1_37 237k
R1_37_28 nx28 s1_37 2.05Meg
R1_37_29 x29 s1_37 210k
R1_37_30 x30 s1_37 130k
R1_37_31 nx31 s1_37 294k
R1_37_32 x32 s1_37 294k
R1_37_33 nx33 s1_37 274k
R1_37_34 nx34 s1_37 681k
R1_37_35 x35 s1_37 732k
R1_37_37 x37 s1_37 2.21Meg
R1_37_38 nx38 s1_37 267k
R1_37_39 nx39 s1_37 150k
R1_37_40 x40 s1_37 1.1Meg
R1_37_41 nx41 s1_37 324k
R1_37_42 x42 s1_37 1.15Meg
R1_37_43 x43 s1_37 324k
R1_37_44 x44 s1_37 866k
R1_37_45 nx45 s1_37 1.87Meg
R1_37_46 nx46 s1_37 665k
R1_37_47 nx47 s1_37 1.4Meg
R1_37_50 x50 s1_37 475k
R1_37_51 x51 s1_37 681k
R1_37_53 x53 s1_37 887k
R1_37_55 nx55 s1_37 309k
R1_37_56 x56 s1_37 2.15Meg
R1_37_57 nx57 s1_37 634k
R1_37_58 nx58 s1_37 442k
R1_37_59 nx59 s1_37 2.05Meg
R1_37_62 nx62 s1_37 768k
R1_37_63 x63 s1_37 191k
RB1_37 bn s1_37 1Meg
XI1_37 bI1_37 si1_37 vcc vee na1_37 LT1810
RBALI1_37 bI1_37 0 50k
RIA1_37 a1_37 si1_37 100k
RIF1_37 na1_37 si1_37 100k
CFRIF1_37 na1_37 si1_37 2p
XS1_38 bS1_38 s1_38 vcc veer a1_38 LT1810
RBALS1_38 bS1_38 0 8.59202k
RF1_38 a1_38 s1_38 100k
CFRF1_38 a1_38 s1_38 2p
R1_38_0 x0 s1_38 825k
R1_38_1 x1 s1_38 511k
R1_38_2 nx2 s1_38 324k
R1_38_3 nx3 s1_38 267k
R1_38_4 x4 s1_38 316k
R1_38_6 nx6 s1_38 845k
R1_38_7 x7 s1_38 402k
R1_38_8 x8 s1_38 787k
R1_38_9 x9 s1_38 1.5Meg
R1_38_10 x10 s1_38 1.5Meg
R1_38_11 x11 s1_38 196k
R1_38_14 nx14 s1_38 3.01Meg
R1_38_15 x15 s1_38 698k
R1_38_17 x17 s1_38 237k
R1_38_18 x18 s1_38 309k
R1_38_19 x19 s1_38 590k
R1_38_20 x20 s1_38 1.5Meg
R1_38_21 nx21 s1_38 1.05Meg
R1_38_22 nx22 s1_38 750k
R1_38_24 x24 s1_38 274k
R1_38_25 x25 s1_38 681k
R1_38_27 x27 s1_38 698k
R1_38_28 x28 s1_38 1.02Meg
R1_38_29 x29 s1_38 619k
R1_38_30 nx30 s1_38 523k
R1_38_31 x31 s1_38 619k
R1_38_32 x32 s1_38 287k
R1_38_34 x34 s1_38 665k
R1_38_35 x35 s1_38 549k
R1_38_36 x36 s1_38 255k
R1_38_37 x37 s1_38 562k
R1_38_40 x40 s1_38 332k
R1_38_41 x41 s1_38 634k
R1_38_42 nx42 s1_38 2.55Meg
R1_38_44 x44 s1_38 301k
R1_38_45 x45 s1_38 845k
R1_38_46 x46 s1_38 287k
R1_38_47 x47 s1_38 619k
R1_38_49 x49 s1_38 1.13Meg
R1_38_50 nx50 s1_38 412k
R1_38_51 x51 s1_38 2.26Meg
R1_38_52 x52 s1_38 1.02Meg
R1_38_53 x53 s1_38 576k
R1_38_54 x54 s1_38 523k
R1_38_55 nx55 s1_38 324k
R1_38_56 nx56 s1_38 649k
R1_38_57 x57 s1_38 287k
R1_38_58 x58 s1_38 499k
R1_38_59 x59 s1_38 634k
R1_38_60 nx60 s1_38 237k
R1_38_61 x61 s1_38 909k
R1_38_62 nx62 s1_38 1.15Meg
R1_38_63 x63 s1_38 806k
RB1_38 bp s1_38 1.43Meg
XI1_38 bI1_38 si1_38 vcc vee na1_38 LT1810
RBALI1_38 bI1_38 0 50k
RIA1_38 a1_38 si1_38 100k
RIF1_38 na1_38 si1_38 100k
CFRIF1_38 na1_38 si1_38 2p
XS1_39 bS1_39 s1_39 vcc veer a1_39 LT1810
RBALS1_39 bS1_39 0 5.8303k
RF1_39 a1_39 s1_39 100k
CFRF1_39 a1_39 s1_39 2p
R1_39_0 nx0 s1_39 169k
R1_39_1 nx1 s1_39 200k
R1_39_2 nx2 s1_39 1.18Meg
R1_39_4 nx4 s1_39 294k
R1_39_5 nx5 s1_39 261k
R1_39_6 nx6 s1_39 309k
R1_39_7 nx7 s1_39 174k
R1_39_8 nx8 s1_39 127k
R1_39_9 nx9 s1_39 324k
R1_39_10 x10 s1_39 715k
R1_39_11 x11 s1_39 191k
R1_39_12 x12 s1_39 768k
R1_39_13 nx13 s1_39 243k
R1_39_15 nx15 s1_39 210k
R1_39_16 nx16 s1_39 221k
R1_39_17 nx17 s1_39 1.24Meg
R1_39_18 nx18 s1_39 976k
R1_39_19 x19 s1_39 1.69Meg
R1_39_20 nx20 s1_39 604k
R1_39_21 nx21 s1_39 301k
R1_39_22 nx22 s1_39 422k
R1_39_24 nx24 s1_39 634k
R1_39_26 nx26 s1_39 2.32Meg
R1_39_28 nx28 s1_39 340k
R1_39_29 nx29 s1_39 221k
R1_39_30 x30 s1_39 226k
R1_39_31 x31 s1_39 121k
R1_39_32 nx32 s1_39 1.02Meg
R1_39_33 x33 s1_39 383k
R1_39_35 nx35 s1_39 475k
R1_39_36 nx36 s1_39 619k
R1_39_37 x37 s1_39 301k
R1_39_38 nx38 s1_39 422k
R1_39_39 nx39 s1_39 768k
R1_39_40 nx40 s1_39 340k
R1_39_42 x42 s1_39 316k
R1_39_45 x45 s1_39 392k
R1_39_46 nx46 s1_39 267k
R1_39_47 nx47 s1_39 715k
R1_39_48 nx48 s1_39 536k
R1_39_49 nx49 s1_39 787k
R1_39_50 x50 s1_39 562k
R1_39_51 x51 s1_39 2.21Meg
R1_39_52 nx52 s1_39 1.1Meg
R1_39_53 nx53 s1_39 464k
R1_39_54 nx54 s1_39 464k
R1_39_55 x55 s1_39 127k
R1_39_56 nx56 s1_39 309k
R1_39_57 x57 s1_39 464k
R1_39_58 x58 s1_39 243k
R1_39_59 x59 s1_39 412k
R1_39_60 nx60 s1_39 750k
R1_39_62 x62 s1_39 205k
R1_39_63 x63 s1_39 249k
RB1_39 bn s1_39 1.74Meg
XI1_39 bI1_39 si1_39 vcc vee na1_39 LT1810
RBALI1_39 bI1_39 0 50k
RIA1_39 a1_39 si1_39 100k
RIF1_39 na1_39 si1_39 100k
CFRIF1_39 na1_39 si1_39 2p
XS1_40 bS1_40 s1_40 vcc veer a1_40 LT1810
RBALS1_40 bS1_40 0 4.79405k
RF1_40 a1_40 s1_40 100k
CFRF1_40 a1_40 s1_40 2p
R1_40_0 x0 s1_40 976k
R1_40_1 nx1 s1_40 348k
R1_40_2 nx2 s1_40 267k
R1_40_3 nx3 s1_40 287k
R1_40_4 nx4 s1_40 309k
R1_40_6 x6 s1_40 249k
R1_40_7 nx7 s1_40 1.58Meg
R1_40_8 nx8 s1_40 127k
R1_40_9 x9 s1_40 392k
R1_40_10 nx10 s1_40 698k
R1_40_11 nx11 s1_40 475k
R1_40_12 nx12 s1_40 909k
R1_40_13 nx13 s1_40 294k
R1_40_14 nx14 s1_40 324k
R1_40_15 nx15 s1_40 1.5Meg
R1_40_16 x16 s1_40 226k
R1_40_17 x17 s1_40 294k
R1_40_18 x18 s1_40 1.02Meg
R1_40_19 x19 s1_40 1.5Meg
R1_40_20 x20 s1_40 232k
R1_40_21 x21 s1_40 232k
R1_40_22 x22 s1_40 332k
R1_40_23 x23 s1_40 162k
R1_40_24 x24 s1_40 634k
R1_40_25 nx25 s1_40 226k
R1_40_26 nx26 s1_40 261k
R1_40_27 nx27 s1_40 182k
R1_40_28 x28 s1_40 301k
R1_40_29 x29 s1_40 147k
R1_40_30 x30 s1_40 86.6k
R1_40_31 x31 s1_40 95.3k
R1_40_32 x32 s1_40 165k
R1_40_33 nx33 s1_40 845k
R1_40_34 nx34 s1_40 1.05Meg
R1_40_35 x35 s1_40 261k
R1_40_37 nx37 s1_40 825k
R1_40_38 nx38 s1_40 715k
R1_40_39 nx39 s1_40 562k
R1_40_40 x40 s1_40 549k
R1_40_41 x41 s1_40 196k
R1_40_43 x43 s1_40 2.1Meg
R1_40_44 x44 s1_40 249k
R1_40_45 nx45 s1_40 576k
R1_40_46 nx46 s1_40 255k
R1_40_47 nx47 s1_40 237k
R1_40_48 nx48 s1_40 412k
R1_40_49 x49 s1_40 191k
R1_40_51 x51 s1_40 255k
R1_40_52 nx52 s1_40 442k
R1_40_53 x53 s1_40 3.01Meg
R1_40_54 nx54 s1_40 499k
R1_40_55 nx55 s1_40 402k
R1_40_56 x56 s1_40 374k
R1_40_57 nx57 s1_40 143k
R1_40_58 nx58 s1_40 845k
R1_40_59 nx59 s1_40 158k
R1_40_60 nx60 s1_40 549k
R1_40_61 nx61 s1_40 976k
R1_40_62 x62 s1_40 825k
R1_40_63 x63 s1_40 280k
RB1_40 bn s1_40 715k
XI1_40 bI1_40 si1_40 vcc vee na1_40 LT1810
RBALI1_40 bI1_40 0 50k
RIA1_40 a1_40 si1_40 100k
RIF1_40 na1_40 si1_40 100k
CFRIF1_40 na1_40 si1_40 2p
XS1_41 bS1_41 s1_41 vcc veer a1_41 LT1810
RBALS1_41 bS1_41 0 5.61051k
RF1_41 a1_41 s1_41 100k
CFRF1_41 a1_41 s1_41 2p
R1_41_0 nx0 s1_41 383k
R1_41_1 x1 s1_41 267k
R1_41_3 nx3 s1_41 604k
R1_41_6 nx6 s1_41 1.15Meg
R1_41_7 nx7 s1_41 365k
R1_41_8 nx8 s1_41 453k
R1_41_9 nx9 s1_41 2.32Meg
R1_41_10 nx10 s1_41 634k
R1_41_11 nx11 s1_41 1.33Meg
R1_41_12 nx12 s1_41 768k
R1_41_14 nx14 s1_41 787k
R1_41_15 nx15 s1_41 536k
R1_41_16 nx16 s1_41 154k
R1_41_18 x18 s1_41 1.65Meg
R1_41_19 x19 s1_41 1Meg
R1_41_20 x20 s1_41 1.21Meg
R1_41_21 nx21 s1_41 1.54Meg
R1_41_22 nx22 s1_41 422k
R1_41_23 nx23 s1_41 464k
R1_41_24 nx24 s1_41 178k
R1_41_25 x25 s1_41 357k
R1_41_26 x26 s1_41 511k
R1_41_27 nx27 s1_41 1.33Meg
R1_41_29 x29 s1_41 316k
R1_41_30 x30 s1_41 255k
R1_41_31 x31 s1_41 634k
R1_41_32 x32 s1_41 412k
R1_41_33 x33 s1_41 215k
R1_41_34 nx34 s1_41 316k
R1_41_35 nx35 s1_41 162k
R1_41_36 nx36 s1_41 2.37Meg
R1_41_39 x39 s1_41 165k
R1_41_40 nx40 s1_41 649k
R1_41_41 x41 s1_41 110k
R1_41_42 x42 s1_41 95.3k
R1_41_43 x43 s1_41 169k
R1_41_45 nx45 s1_41 523k
R1_41_46 nx46 s1_41 475k
R1_41_47 x47 s1_41 261k
R1_41_48 nx48 s1_41 280k
R1_41_49 nx49 s1_41 357k
R1_41_50 nx50 s1_41 432k
R1_41_52 x52 s1_41 1.15Meg
R1_41_53 x53 s1_41 576k
R1_41_54 x54 s1_41 1.74Meg
R1_41_55 x55 s1_41 102k
R1_41_56 nx56 s1_41 150k
R1_41_57 nx57 s1_41 162k
R1_41_58 nx58 s1_41 237k
R1_41_59 nx59 s1_41 475k
R1_41_61 x61 s1_41 732k
R1_41_62 x62 s1_41 287k
R1_41_63 x63 s1_41 110k
RB1_41 bp s1_41 1.33Meg
XI1_41 bI1_41 si1_41 vcc vee na1_41 LT1810
RBALI1_41 bI1_41 0 50k
RIA1_41 a1_41 si1_41 100k
RIF1_41 na1_41 si1_41 100k
CFRIF1_41 na1_41 si1_41 2p
XS1_42 bS1_42 s1_42 vcc veer a1_42 LT1810
RBALS1_42 bS1_42 0 5.28107k
RF1_42 a1_42 s1_42 100k
CFRF1_42 a1_42 s1_42 2p
R1_42_0 x0 s1_42 243k
R1_42_1 x1 s1_42 154k
R1_42_2 x2 s1_42 523k
R1_42_3 x3 s1_42 200k
R1_42_4 x4 s1_42 340k
R1_42_5 nx5 s1_42 1.05Meg
R1_42_6 nx6 s1_42 301k
R1_42_7 nx7 s1_42 280k
R1_42_8 x8 s1_42 191k
R1_42_9 x9 s1_42 357k
R1_42_10 x10 s1_42 324k
R1_42_12 nx12 s1_42 324k
R1_42_13 nx13 s1_42 294k
R1_42_14 nx14 s1_42 140k
R1_42_15 nx15 s1_42 115k
R1_42_17 x17 s1_42 118k
R1_42_18 nx18 s1_42 1.62Meg
R1_42_20 x20 s1_42 221k
R1_42_21 x21 s1_42 93.1k
R1_42_22 x22 s1_42 64.9k
R1_42_23 x23 s1_42 88.7k
R1_42_24 x24 s1_42 280k
R1_42_26 nx26 s1_42 1.82Meg
R1_42_27 nx27 s1_42 402k
R1_42_28 x28 s1_42 1.27Meg
R1_42_29 x29 s1_42 2.26Meg
R1_42_30 x30 s1_42 374k
R1_42_31 x31 s1_42 143k
R1_42_34 nx34 s1_42 931k
R1_42_36 x36 s1_42 698k
R1_42_37 nx37 s1_42 549k
R1_42_38 nx38 s1_42 267k
R1_42_39 x39 s1_42 243k
R1_42_40 nx40 s1_42 412k
R1_42_42 nx42 s1_42 1.05Meg
R1_42_43 nx43 s1_42 392k
R1_42_45 x45 s1_42 845k
R1_42_47 x47 s1_42 523k
R1_42_48 nx48 s1_42 226k
R1_42_49 x49 s1_42 324k
R1_42_50 x50 s1_42 1.27Meg
R1_42_51 nx51 s1_42 475k
R1_42_52 nx52 s1_42 590k
R1_42_53 x53 s1_42 1.74Meg
R1_42_54 nx54 s1_42 665k
R1_42_55 nx55 s1_42 1Meg
R1_42_56 nx56 s1_42 464k
R1_42_57 nx57 s1_42 1Meg
R1_42_59 x59 s1_42 221k
R1_42_60 nx60 s1_42 1.02Meg
R1_42_61 x61 s1_42 787k
R1_42_62 x62 s1_42 604k
RB1_42 bn s1_42 931k
XI1_42 bI1_42 si1_42 vcc vee na1_42 LT1810
RBALI1_42 bI1_42 0 50k
RIA1_42 a1_42 si1_42 100k
RIF1_42 na1_42 si1_42 100k
CFRIF1_42 na1_42 si1_42 2p
XS1_43 bS1_43 s1_43 vcc veer a1_43 LT1810
RBALS1_43 bS1_43 0 7.00874k
RF1_43 a1_43 s1_43 100k
CFRF1_43 a1_43 s1_43 2p
R1_43_0 x0 s1_43 1.05Meg
R1_43_1 nx1 s1_43 162k
R1_43_2 nx2 s1_43 169k
R1_43_4 nx4 s1_43 768k
R1_43_5 nx5 s1_43 442k
R1_43_6 nx6 s1_43 1.69Meg
R1_43_8 nx8 s1_43 178k
R1_43_9 x9 s1_43 931k
R1_43_11 x11 s1_43 1.05Meg
R1_43_13 nx13 s1_43 2.37Meg
R1_43_14 x14 s1_43 825k
R1_43_15 x15 s1_43 196k
R1_43_16 nx16 s1_43 392k
R1_43_17 x17 s1_43 348k
R1_43_18 x18 s1_43 976k
R1_43_19 x19 s1_43 374k
R1_43_20 nx20 s1_43 931k
R1_43_21 nx21 s1_43 1.43Meg
R1_43_23 x23 s1_43 1.91Meg
R1_43_25 nx25 s1_43 475k
R1_43_26 x26 s1_43 604k
R1_43_27 x27 s1_43 887k
R1_43_28 x28 s1_43 147k
R1_43_29 x29 s1_43 301k
R1_43_30 nx30 s1_43 287k
R1_43_31 nx31 s1_43 102k
R1_43_32 nx32 s1_43 332k
R1_43_33 x33 s1_43 2.26Meg
R1_43_34 nx34 s1_43 232k
R1_43_35 x35 s1_43 357k
R1_43_36 nx36 s1_43 1.27Meg
R1_43_38 nx38 s1_43 340k
R1_43_39 nx39 s1_43 324k
R1_43_41 nx41 s1_43 619k
R1_43_42 nx42 s1_43 249k
R1_43_43 nx43 s1_43 187k
R1_43_44 nx44 s1_43 1.69Meg
R1_43_45 nx45 s1_43 412k
R1_43_47 x47 s1_43 953k
R1_43_48 nx48 s1_43 442k
R1_43_49 nx49 s1_43 562k
R1_43_50 nx50 s1_43 261k
R1_43_52 x52 s1_43 1.4Meg
R1_43_53 x53 s1_43 1.33Meg
R1_43_54 x54 s1_43 1.78Meg
R1_43_55 nx55 s1_43 976k
R1_43_56 nx56 s1_43 274k
R1_43_57 x57 s1_43 174k
R1_43_59 x59 s1_43 1.74Meg
R1_43_60 x60 s1_43 432k
R1_43_62 x62 s1_43 1.91Meg
R1_43_63 x63 s1_43 210k
RB1_43 bn s1_43 2.21Meg
XI1_43 bI1_43 si1_43 vcc vee na1_43 LT1810
RBALI1_43 bI1_43 0 50k
RIA1_43 a1_43 si1_43 100k
RIF1_43 na1_43 si1_43 100k
CFRIF1_43 na1_43 si1_43 2p
XS1_44 bS1_44 s1_44 vcc veer a1_44 LT1810
RBALS1_44 bS1_44 0 6.04883k
RF1_44 a1_44 s1_44 100k
CFRF1_44 a1_44 s1_44 2p
R1_44_0 nx0 s1_44 187k
R1_44_1 nx1 s1_44 536k
R1_44_3 x3 s1_44 442k
R1_44_4 x4 s1_44 402k
R1_44_5 nx5 s1_44 2.43Meg
R1_44_6 nx6 s1_44 274k
R1_44_7 x7 s1_44 191k
R1_44_8 nx8 s1_44 536k
R1_44_9 x9 s1_44 261k
R1_44_10 x10 s1_44 487k
R1_44_11 x11 s1_44 909k
R1_44_12 x12 s1_44 806k
R1_44_13 nx13 s1_44 412k
R1_44_14 nx14 s1_44 1.43Meg
R1_44_15 x15 s1_44 2.21Meg
R1_44_16 x16 s1_44 6.19Meg
R1_44_17 nx17 s1_44 604k
R1_44_18 nx18 s1_44 255k
R1_44_19 x19 s1_44 158k
R1_44_20 nx20 s1_44 1.43Meg
R1_44_21 nx21 s1_44 301k
R1_44_22 x22 s1_44 1.15Meg
R1_44_23 nx23 s1_44 2.26Meg
R1_44_24 x24 s1_44 1.47Meg
R1_44_25 nx25 s1_44 402k
R1_44_26 x26 s1_44 332k
R1_44_27 x27 s1_44 232k
R1_44_28 nx28 s1_44 294k
R1_44_29 x29 s1_44 1.37Meg
R1_44_30 x30 s1_44 499k
R1_44_31 nx31 s1_44 2.15Meg
R1_44_32 x32 s1_44 261k
R1_44_33 x33 s1_44 280k
R1_44_34 x34 s1_44 205k
R1_44_36 nx36 s1_44 348k
R1_44_37 x37 s1_44 422k
R1_44_38 x38 s1_44 442k
R1_44_39 x39 s1_44 249k
R1_44_40 nx40 s1_44 267k
R1_44_41 nx41 s1_44 909k
R1_44_42 x42 s1_44 715k
R1_44_43 nx43 s1_44 2.61Meg
R1_44_44 x44 s1_44 267k
R1_44_45 x45 s1_44 93.1k
R1_44_46 x46 s1_44 249k
R1_44_47 x47 s1_44 536k
R1_44_48 nx48 s1_44 453k
R1_44_49 nx49 s1_44 562k
R1_44_50 nx50 s1_44 316k
R1_44_51 nx51 s1_44 243k
R1_44_52 nx52 s1_44 887k
R1_44_53 nx53 s1_44 187k
R1_44_54 nx54 s1_44 294k
R1_44_56 nx56 s1_44 1.02Meg
R1_44_57 nx57 s1_44 1.02Meg
R1_44_58 x58 s1_44 432k
R1_44_59 nx59 s1_44 2.1Meg
R1_44_60 x60 s1_44 1.1Meg
R1_44_62 nx62 s1_44 267k
R1_44_63 nx63 s1_44 267k
RB1_44 bn s1_44 1.24Meg
XI1_44 bI1_44 si1_44 vcc vee na1_44 LT1810
RBALI1_44 bI1_44 0 50k
RIA1_44 a1_44 si1_44 100k
RIF1_44 na1_44 si1_44 100k
CFRIF1_44 na1_44 si1_44 2p
XS1_45 bS1_45 s1_45 vcc veer a1_45 LT1810
RBALS1_45 bS1_45 0 6.56704k
RF1_45 a1_45 s1_45 100k
CFRF1_45 a1_45 s1_45 2p
R1_45_0 x0 s1_45 953k
R1_45_2 nx2 s1_45 1.05Meg
R1_45_3 x3 s1_45 576k
R1_45_4 nx4 s1_45 715k
R1_45_5 nx5 s1_45 178k
R1_45_6 nx6 s1_45 226k
R1_45_7 nx7 s1_45 280k
R1_45_8 x8 s1_45 255k
R1_45_9 x9 s1_45 324k
R1_45_10 nx10 s1_45 412k
R1_45_11 nx11 s1_45 681k
R1_45_13 x13 s1_45 324k
R1_45_15 nx15 s1_45 226k
R1_45_16 x16 s1_45 1.74Meg
R1_45_17 nx17 s1_45 165k
R1_45_18 nx18 s1_45 332k
R1_45_19 nx19 s1_45 178k
R1_45_20 x20 s1_45 511k
R1_45_21 x21 s1_45 294k
R1_45_22 x22 s1_45 1.96Meg
R1_45_23 x23 s1_45 953k
R1_45_24 nx24 s1_45 115k
R1_45_25 nx25 s1_45 243k
R1_45_26 x26 s1_45 536k
R1_45_27 nx27 s1_45 604k
R1_45_28 nx28 s1_45 487k
R1_45_29 x29 s1_45 511k
R1_45_30 nx30 s1_45 715k
R1_45_31 nx31 s1_45 205k
R1_45_32 x32 s1_45 2.26Meg
R1_45_33 x33 s1_45 562k
R1_45_35 nx35 s1_45 221k
R1_45_36 nx36 s1_45 267k
R1_45_37 x37 s1_45 768k
R1_45_38 nx38 s1_45 511k
R1_45_40 x40 s1_45 324k
R1_45_41 nx41 s1_45 619k
R1_45_42 nx42 s1_45 931k
R1_45_43 nx43 s1_45 681k
R1_45_44 x44 s1_45 280k
R1_45_45 x45 s1_45 200k
R1_45_46 x46 s1_45 1.1Meg
R1_45_47 nx47 s1_45 422k
R1_45_48 x48 s1_45 1.78Meg
R1_45_49 x49 s1_45 523k
R1_45_51 x51 s1_45 1.1Meg
R1_45_52 x52 s1_45 887k
R1_45_53 nx53 s1_45 1.87Meg
R1_45_54 x54 s1_45 1.21Meg
R1_45_55 x55 s1_45 249k
R1_45_56 x56 s1_45 1.58Meg
R1_45_57 nx57 s1_45 511k
R1_45_58 nx58 s1_45 511k
R1_45_60 x60 s1_45 665k
R1_45_62 nx62 s1_45 619k
R1_45_63 x63 s1_45 196k
RB1_45 bn s1_45 1.24Meg
XI1_45 bI1_45 si1_45 vcc vee na1_45 LT1810
RBALI1_45 bI1_45 0 50k
RIA1_45 a1_45 si1_45 100k
RIF1_45 na1_45 si1_45 100k
CFRIF1_45 na1_45 si1_45 2p
XS1_46 bS1_46 s1_46 vcc veer a1_46 LT1810
RBALS1_46 bS1_46 0 6.40392k
RF1_46 a1_46 s1_46 100k
CFRF1_46 a1_46 s1_46 2p
R1_46_0 x0 s1_46 143k
R1_46_1 x1 s1_46 511k
R1_46_2 x2 s1_46 453k
R1_46_3 nx3 s1_46 604k
R1_46_5 x5 s1_46 475k
R1_46_6 nx6 s1_46 715k
R1_46_7 x7 s1_46 232k
R1_46_8 nx8 s1_46 1.4Meg
R1_46_9 nx9 s1_46 2.37Meg
R1_46_10 x10 s1_46 1.37Meg
R1_46_12 nx12 s1_46 715k
R1_46_13 x13 s1_46 768k
R1_46_14 x14 s1_46 634k
R1_46_15 x15 s1_46 1.62Meg
R1_46_16 nx16 s1_46 316k
R1_46_17 nx17 s1_46 1.47Meg
R1_46_20 nx20 s1_46 226k
R1_46_21 nx21 s1_46 162k
R1_46_22 x22 s1_46 487k
R1_46_23 nx23 s1_46 1.82Meg
R1_46_24 x24 s1_46 422k
R1_46_25 nx25 s1_46 1.1Meg
R1_46_27 nx27 s1_46 619k
R1_46_28 x28 s1_46 487k
R1_46_29 nx29 s1_46 487k
R1_46_30 x30 s1_46 619k
R1_46_31 x31 s1_46 124k
R1_46_32 nx32 s1_46 174k
R1_46_33 nx33 s1_46 215k
R1_46_34 nx34 s1_46 365k
R1_46_35 nx35 s1_46 348k
R1_46_36 nx36 s1_46 549k
R1_46_37 nx37 s1_46 178k
R1_46_38 nx38 s1_46 165k
R1_46_39 nx39 s1_46 232k
R1_46_40 nx40 s1_46 732k
R1_46_41 nx41 s1_46 348k
R1_46_42 nx42 s1_46 261k
R1_46_43 x43 s1_46 402k
R1_46_46 x46 s1_46 1.4Meg
R1_46_47 nx47 s1_46 1.37Meg
R1_46_49 x49 s1_46 2.67Meg
R1_46_51 x51 s1_46 909k
R1_46_52 x52 s1_46 649k
R1_46_53 x53 s1_46 604k
R1_46_54 x54 s1_46 487k
R1_46_55 x55 s1_46 205k
R1_46_56 x56 s1_46 118k
R1_46_57 x57 s1_46 536k
R1_46_58 nx58 s1_46 464k
R1_46_59 nx59 s1_46 698k
R1_46_60 x60 s1_46 1.27Meg
R1_46_61 x61 s1_46 205k
R1_46_62 x62 s1_46 280k
R1_46_63 nx63 s1_46 590k
RB1_46 bp s1_46 1.33Meg
XI1_46 bI1_46 si1_46 vcc vee na1_46 LT1810
RBALI1_46 bI1_46 0 50k
RIA1_46 a1_46 si1_46 100k
RIF1_46 na1_46 si1_46 100k
CFRIF1_46 na1_46 si1_46 2p
XS1_47 bS1_47 s1_47 vcc veer a1_47 LT1810
RBALS1_47 bS1_47 0 4.99573k
RF1_47 a1_47 s1_47 100k
CFRF1_47 a1_47 s1_47 2p
R1_47_0 x0 s1_47 165k
R1_47_1 x1 s1_47 374k
R1_47_2 x2 s1_47 169k
R1_47_3 x3 s1_47 422k
R1_47_4 x4 s1_47 392k
R1_47_6 nx6 s1_47 402k
R1_47_7 nx7 s1_47 237k
R1_47_8 nx8 s1_47 140k
R1_47_9 x9 s1_47 124k
R1_47_10 x10 s1_47 237k
R1_47_11 x11 s1_47 665k
R1_47_13 x13 s1_47 523k
R1_47_14 x14 s1_47 267k
R1_47_15 nx15 s1_47 374k
R1_47_16 nx16 s1_47 124k
R1_47_17 x17 s1_47 274k
R1_47_18 x18 s1_47 158k
R1_47_19 nx19 s1_47 1.37Meg
R1_47_20 nx20 s1_47 487k
R1_47_21 x21 s1_47 412k
R1_47_22 x22 s1_47 243k
R1_47_24 nx24 s1_47 196k
R1_47_25 x25 s1_47 523k
R1_47_26 nx26 s1_47 255k
R1_47_27 nx27 s1_47 127k
R1_47_28 x28 s1_47 1.24Meg
R1_47_29 nx29 s1_47 309k
R1_47_31 x31 s1_47 124k
R1_47_32 nx32 s1_47 619k
R1_47_33 nx33 s1_47 1.3Meg
R1_47_34 nx34 s1_47 576k
R1_47_36 nx36 s1_47 1.15Meg
R1_47_37 nx37 s1_47 412k
R1_47_38 x38 s1_47 392k
R1_47_39 x39 s1_47 133k
R1_47_40 x40 s1_47 340k
R1_47_41 nx41 s1_47 1.87Meg
R1_47_42 x42 s1_47 499k
R1_47_44 nx44 s1_47 511k
R1_47_46 x46 s1_47 182k
R1_47_47 x47 s1_47 118k
R1_47_48 x48 s1_47 255k
R1_47_49 x49 s1_47 499k
R1_47_50 x50 s1_47 523k
R1_47_51 nx51 s1_47 1.82Meg
R1_47_52 x52 s1_47 340k
R1_47_53 x53 s1_47 806k
R1_47_54 x54 s1_47 649k
R1_47_55 x55 s1_47 113k
R1_47_56 x56 s1_47 422k
R1_47_57 x57 s1_47 619k
R1_47_60 nx60 s1_47 2Meg
R1_47_61 nx61 s1_47 374k
R1_47_62 nx62 s1_47 196k
R1_47_63 x63 s1_47 604k
RB1_47 bn s1_47 1.74Meg
XI1_47 bI1_47 si1_47 vcc vee na1_47 LT1810
RBALI1_47 bI1_47 0 50k
RIA1_47 a1_47 si1_47 100k
RIF1_47 na1_47 si1_47 100k
CFRIF1_47 na1_47 si1_47 2p
* ---- stage 2: 48 -> 32 (hidden, single-supply ReLU)
XS2_0 bS2_0 s2_0 vcc veer a2_0 LT1810
RBALS2_0 bS2_0 0 5.87514k
RF2_0 a2_0 s2_0 100k
CFRF2_0 a2_0 s2_0 2p
R2_0_0 a1_0 s2_0 309k
R2_0_1 na1_1 s2_0 340k
R2_0_2 na1_2 s2_0 2.87Meg
R2_0_3 na1_3 s2_0 121k
R2_0_4 na1_4 s2_0 1.13Meg
R2_0_5 a1_5 s2_0 249k
R2_0_6 a1_6 s2_0 210k
R2_0_7 a1_7 s2_0 267k
R2_0_8 na1_8 s2_0 536k
R2_0_9 a1_9 s2_0 499k
R2_0_10 a1_10 s2_0 237k
R2_0_11 na1_11 s2_0 649k
R2_0_12 a1_12 s2_0 287k
R2_0_13 na1_13 s2_0 267k
R2_0_14 na1_14 s2_0 1.05Meg
R2_0_15 a1_15 s2_0 215k
R2_0_17 a1_17 s2_0 1.1Meg
R2_0_18 na1_18 s2_0 316k
R2_0_19 na1_19 s2_0 866k
R2_0_20 na1_20 s2_0 261k
R2_0_21 na1_21 s2_0 590k
R2_0_22 na1_22 s2_0 634k
R2_0_23 a1_23 s2_0 187k
R2_0_24 a1_24 s2_0 196k
R2_0_25 na1_25 s2_0 140k
R2_0_28 a1_28 s2_0 787k
R2_0_29 a1_29 s2_0 221k
R2_0_30 a1_30 s2_0 215k
R2_0_31 a1_31 s2_0 154k
R2_0_32 na1_32 s2_0 158k
R2_0_33 na1_33 s2_0 118k
R2_0_34 a1_34 s2_0 232k
R2_0_35 na1_35 s2_0 649k
R2_0_36 na1_36 s2_0 137k
R2_0_37 na1_37 s2_0 210k
R2_0_38 a1_38 s2_0 487k
R2_0_39 na1_39 s2_0 511k
R2_0_40 a1_40 s2_0 1.21Meg
R2_0_41 a1_41 s2_0 205k
R2_0_42 na1_42 s2_0 324k
R2_0_43 a1_43 s2_0 162k
R2_0_45 na1_45 s2_0 340k
R2_0_46 na1_46 s2_0 392k
R2_0_47 na1_47 s2_0 200k
RB2_0 bn s2_0 2Meg
XI2_0 bI2_0 si2_0 vcc vee na2_0 LT1810
RBALI2_0 bI2_0 0 50k
RIA2_0 a2_0 si2_0 100k
RIF2_0 na2_0 si2_0 100k
CFRIF2_0 na2_0 si2_0 2p
XS2_1 bS2_1 s2_1 vcc veer a2_1 LT1810
RBALS2_1 bS2_1 0 7.32958k
RF2_1 a2_1 s2_1 100k
CFRF2_1 a2_1 s2_1 2p
R2_1_1 a1_1 s2_1 732k
R2_1_2 na1_2 s2_1 698k
R2_1_3 na1_3 s2_1 348k
R2_1_4 na1_4 s2_1 274k
R2_1_5 a1_5 s2_1 365k
R2_1_6 na1_6 s2_1 140k
R2_1_7 na1_7 s2_1 442k
R2_1_8 na1_8 s2_1 511k
R2_1_9 na1_9 s2_1 147k
R2_1_10 na1_10 s2_1 169k
R2_1_11 na1_11 s2_1 464k
R2_1_13 a1_13 s2_1 487k
R2_1_14 a1_14 s2_1 154k
R2_1_15 a1_15 s2_1 750k
R2_1_16 a1_16 s2_1 464k
R2_1_17 na1_17 s2_1 866k
R2_1_18 a1_18 s2_1 1.33Meg
R2_1_19 a1_19 s2_1 316k
R2_1_20 na1_20 s2_1 453k
R2_1_21 a1_21 s2_1 402k
R2_1_22 na1_22 s2_1 1.18Meg
R2_1_23 a1_23 s2_1 309k
R2_1_25 a1_25 s2_1 1.13Meg
R2_1_26 na1_26 s2_1 1.07Meg
R2_1_27 na1_27 s2_1 432k
R2_1_28 a1_28 s2_1 649k
R2_1_29 na1_29 s2_1 1.4Meg
R2_1_30 na1_30 s2_1 1.07Meg
R2_1_31 a1_31 s2_1 1Meg
R2_1_32 na1_32 s2_1 332k
R2_1_33 na1_33 s2_1 226k
R2_1_35 na1_35 s2_1 232k
R2_1_36 a1_36 s2_1 162k
R2_1_37 na1_37 s2_1 158k
R2_1_38 a1_38 s2_1 665k
R2_1_39 na1_39 s2_1 226k
R2_1_40 na1_40 s2_1 210k
R2_1_41 na1_41 s2_1 634k
R2_1_42 a1_42 s2_1 768k
R2_1_44 a1_44 s2_1 158k
R2_1_45 na1_45 s2_1 732k
R2_1_46 a1_46 s2_1 825k
R2_1_47 a1_47 s2_1 221k
RB2_1 bn s2_1 374k
XI2_1 bI2_1 si2_1 vcc vee na2_1 LT1810
RBALI2_1 bI2_1 0 50k
RIA2_1 a2_1 si2_1 100k
RIF2_1 na2_1 si2_1 100k
CFRIF2_1 na2_1 si2_1 2p
XS2_2 bS2_2 s2_2 vcc veer a2_2 LT1810
RBALS2_2 bS2_2 0 5.64613k
RF2_2 a2_2 s2_2 100k
CFRF2_2 a2_2 s2_2 2p
R2_2_0 na1_0 s2_2 1.15Meg
R2_2_1 na1_1 s2_2 357k
R2_2_2 a1_2 s2_2 1.91Meg
R2_2_3 a1_3 s2_2 1.07Meg
R2_2_4 a1_4 s2_2 249k
R2_2_5 a1_5 s2_2 274k
R2_2_6 na1_6 s2_2 604k
R2_2_7 a1_7 s2_2 442k
R2_2_8 na1_8 s2_2 887k
R2_2_9 na1_9 s2_2 174k
R2_2_10 a1_10 s2_2 97.6k
R2_2_11 na1_11 s2_2 374k
R2_2_12 na1_12 s2_2 432k
R2_2_13 a1_13 s2_2 174k
R2_2_14 a1_14 s2_2 475k
R2_2_15 a1_15 s2_2 402k
R2_2_17 a1_17 s2_2 698k
R2_2_19 a1_19 s2_2 107k
R2_2_20 a1_20 s2_2 432k
R2_2_21 a1_21 s2_2 165k
R2_2_22 a1_22 s2_2 392k
R2_2_23 na1_23 s2_2 237k
R2_2_24 na1_24 s2_2 475k
R2_2_25 a1_25 s2_2 249k
R2_2_26 a1_26 s2_2 243k
R2_2_27 na1_27 s2_2 475k
R2_2_28 na1_28 s2_2 255k
R2_2_29 na1_29 s2_2 280k
R2_2_30 a1_30 s2_2 187k
R2_2_31 a1_31 s2_2 93.1k
R2_2_32 na1_32 s2_2 1.43Meg
R2_2_33 a1_33 s2_2 215k
R2_2_34 na1_34 s2_2 365k
R2_2_35 na1_35 s2_2 226k
R2_2_36 na1_36 s2_2 402k
R2_2_37 a1_37 s2_2 324k
R2_2_38 a1_38 s2_2 1.65Meg
R2_2_39 a1_39 s2_2 604k
R2_2_40 na1_40 s2_2 301k
R2_2_41 a1_41 s2_2 187k
R2_2_42 na1_42 s2_2 383k
R2_2_43 a1_43 s2_2 124k
R2_2_44 a1_44 s2_2 274k
R2_2_45 na1_45 s2_2 143k
R2_2_46 na1_46 s2_2 909k
R2_2_47 a1_47 s2_2 383k
RB2_2 bn s2_2 487k
XI2_2 bI2_2 si2_2 vcc vee na2_2 LT1810
RBALI2_2 bI2_2 0 50k
RIA2_2 a2_2 si2_2 100k
RIF2_2 na2_2 si2_2 100k
CFRIF2_2 na2_2 si2_2 2p
XS2_3 bS2_3 s2_3 vcc veer a2_3 LT1810
RBALS2_3 bS2_3 0 5.9085k
RF2_3 a2_3 s2_3 100k
CFRF2_3 a2_3 s2_3 2p
R2_3_0 na1_0 s2_3 442k
R2_3_1 a1_1 s2_3 150k
R2_3_2 a1_2 s2_3 267k
R2_3_3 na1_3 s2_3 127k
R2_3_4 a1_4 s2_3 287k
R2_3_5 na1_5 s2_3 549k
R2_3_6 a1_6 s2_3 261k
R2_3_7 na1_7 s2_3 1.62Meg
R2_3_8 na1_8 s2_3 475k
R2_3_9 na1_9 s2_3 590k
R2_3_10 a1_10 s2_3 215k
R2_3_11 na1_11 s2_3 249k
R2_3_12 a1_12 s2_3 191k
R2_3_13 a1_13 s2_3 274k
R2_3_14 a1_14 s2_3 806k
R2_3_15 a1_15 s2_3 422k
R2_3_16 a1_16 s2_3 221k
R2_3_17 na1_17 s2_3 1.65Meg
R2_3_18 na1_18 s2_3 681k
R2_3_19 a1_19 s2_3 681k
R2_3_20 na1_20 s2_3 294k
R2_3_22 na1_22 s2_3 191k
R2_3_23 na1_23 s2_3 1.15Meg
R2_3_24 a1_24 s2_3 1.54Meg
R2_3_25 a1_25 s2_3 169k
R2_3_26 a1_26 s2_3 221k
R2_3_27 na1_27 s2_3 169k
R2_3_28 na1_28 s2_3 383k
R2_3_29 na1_29 s2_3 698k
R2_3_30 a1_30 s2_3 133k
R2_3_31 na1_31 s2_3 432k
R2_3_32 na1_32 s2_3 174k
R2_3_33 na1_33 s2_3 1.07Meg
R2_3_34 a1_34 s2_3 825k
R2_3_35 na1_35 s2_3 1.54Meg
R2_3_36 a1_36 s2_3 255k
R2_3_37 a1_37 s2_3 1.18Meg
R2_3_38 a1_38 s2_3 383k
R2_3_39 a1_39 s2_3 1.21Meg
R2_3_40 na1_40 s2_3 107k
R2_3_41 a1_41 s2_3 422k
R2_3_42 na1_42 s2_3 78.7k
R2_3_43 na1_43 s2_3 267k
R2_3_44 na1_44 s2_3 340k
R2_3_45 na1_45 s2_3 499k
R2_3_46 a1_46 s2_3 287k
R2_3_47 na1_47 s2_3 1.07Meg
RB2_3 bn s2_3 806k
XI2_3 bI2_3 si2_3 vcc vee na2_3 LT1810
RBALI2_3 bI2_3 0 50k
RIA2_3 a2_3 si2_3 100k
RIF2_3 na2_3 si2_3 100k
CFRIF2_3 na2_3 si2_3 2p
XS2_4 bS2_4 s2_4 vcc veer a2_4 LT1810
RBALS2_4 bS2_4 0 6.4585k
RF2_4 a2_4 s2_4 100k
CFRF2_4 a2_4 s2_4 2p
R2_4_0 na1_0 s2_4 576k
R2_4_1 a1_1 s2_4 365k
R2_4_2 na1_2 s2_4 576k
R2_4_3 na1_3 s2_4 787k
R2_4_4 na1_4 s2_4 1.65Meg
R2_4_5 na1_5 s2_4 287k
R2_4_6 na1_6 s2_4 187k
R2_4_7 na1_7 s2_4 649k
R2_4_8 na1_8 s2_4 154k
R2_4_9 a1_9 s2_4 340k
R2_4_11 na1_11 s2_4 287k
R2_4_12 a1_12 s2_4 1.74Meg
R2_4_13 na1_13 s2_4 191k
R2_4_14 na1_14 s2_4 143k
R2_4_15 na1_15 s2_4 243k
R2_4_16 na1_16 s2_4 1.65Meg
R2_4_17 na1_17 s2_4 309k
R2_4_18 a1_18 s2_4 383k
R2_4_19 na1_19 s2_4 191k
R2_4_20 na1_20 s2_4 249k
R2_4_21 na1_21 s2_4 432k
R2_4_22 a1_22 s2_4 301k
R2_4_23 a1_23 s2_4 806k
R2_4_24 a1_24 s2_4 402k
R2_4_25 a1_25 s2_4 619k
R2_4_26 a1_26 s2_4 383k
R2_4_27 a1_27 s2_4 226k
R2_4_28 a1_28 s2_4 536k
R2_4_29 a1_29 s2_4 1.62Meg
R2_4_30 a1_30 s2_4 154k
R2_4_31 na1_31 s2_4 698k
R2_4_32 a1_32 s2_4 332k
R2_4_33 a1_33 s2_4 78.7k
R2_4_34 na1_34 s2_4 205k
R2_4_35 na1_35 s2_4 464k
R2_4_36 a1_36 s2_4 931k
R2_4_37 na1_37 s2_4 549k
R2_4_38 a1_38 s2_4 866k
R2_4_40 a1_40 s2_4 237k
R2_4_41 a1_41 s2_4 143k
R2_4_42 a1_42 s2_4 422k
R2_4_43 a1_43 s2_4 453k
R2_4_44 na1_44 s2_4 1.1Meg
R2_4_45 a1_45 s2_4 348k
R2_4_46 a1_46 s2_4 267k
R2_4_47 na1_47 s2_4 576k
RB2_4 bn s2_4 1.82Meg
XI2_4 bI2_4 si2_4 vcc vee na2_4 LT1810
RBALI2_4 bI2_4 0 50k
RIA2_4 a2_4 si2_4 100k
RIF2_4 na2_4 si2_4 100k
CFRIF2_4 na2_4 si2_4 2p
XS2_5 bS2_5 s2_5 vcc veer a2_5 LT1810
RBALS2_5 bS2_5 0 6.43278k
RF2_5 a2_5 s2_5 100k
CFRF2_5 a2_5 s2_5 2p
R2_5_0 a1_0 s2_5 909k
R2_5_2 a1_2 s2_5 105k
R2_5_3 na1_3 s2_5 191k
R2_5_5 a1_5 s2_5 169k
R2_5_6 na1_6 s2_5 287k
R2_5_7 na1_7 s2_5 1.62Meg
R2_5_8 na1_8 s2_5 226k
R2_5_9 na1_9 s2_5 402k
R2_5_10 a1_10 s2_5 301k
R2_5_11 a1_11 s2_5 442k
R2_5_12 a1_12 s2_5 392k
R2_5_13 na1_13 s2_5 453k
R2_5_14 na1_14 s2_5 562k
R2_5_15 na1_15 s2_5 165k
R2_5_16 na1_16 s2_5 332k
R2_5_17 a1_17 s2_5 1.02Meg
R2_5_19 a1_19 s2_5 255k
R2_5_20 a1_20 s2_5 178k
R2_5_22 na1_22 s2_5 576k
R2_5_23 a1_23 s2_5 523k
R2_5_24 na1_24 s2_5 226k
R2_5_25 a1_25 s2_5 133k
R2_5_26 a1_26 s2_5 1.13Meg
R2_5_27 na1_27 s2_5 174k
R2_5_28 na1_28 s2_5 634k
R2_5_29 na1_29 s2_5 178k
R2_5_30 a1_30 s2_5 133k
R2_5_31 na1_31 s2_5 845k
R2_5_32 na1_32 s2_5 665k
R2_5_33 a1_33 s2_5 1.15Meg
R2_5_34 a1_34 s2_5 301k
R2_5_35 a1_35 s2_5 1.5Meg
R2_5_36 na1_36 s2_5 154k
R2_5_37 na1_37 s2_5 523k
R2_5_38 a1_38 s2_5 1.5Meg
R2_5_39 a1_39 s2_5 976k
R2_5_40 a1_40 s2_5 590k
R2_5_41 a1_41 s2_5 158k
R2_5_42 na1_42 s2_5 205k
R2_5_43 na1_43 s2_5 453k
R2_5_44 na1_44 s2_5 133k
R2_5_46 a1_46 s2_5 316k
R2_5_47 a1_47 s2_5 1.74Meg
XI2_5 bI2_5 si2_5 vcc vee na2_5 LT1810
RBALI2_5 bI2_5 0 50k
RIA2_5 a2_5 si2_5 100k
RIF2_5 na2_5 si2_5 100k
CFRIF2_5 na2_5 si2_5 2p
XS2_6 bS2_6 s2_6 vcc veer a2_6 LT1810
RBALS2_6 bS2_6 0 7.30976k
RF2_6 a2_6 s2_6 100k
CFRF2_6 a2_6 s2_6 2p
R2_6_0 a1_0 s2_6 1.87Meg
R2_6_1 na1_1 s2_6 453k
R2_6_2 na1_2 s2_6 340k
R2_6_3 a1_3 s2_6 392k
R2_6_4 na1_4 s2_6 806k
R2_6_5 a1_5 s2_6 1.43Meg
R2_6_6 na1_6 s2_6 845k
R2_6_8 na1_8 s2_6 976k
R2_6_9 na1_9 s2_6 124k
R2_6_10 na1_10 s2_6 374k
R2_6_11 na1_11 s2_6 590k
R2_6_12 na1_12 s2_6 487k
R2_6_13 a1_13 s2_6 215k
R2_6_14 a1_14 s2_6 243k
R2_6_17 na1_17 s2_6 221k
R2_6_18 na1_18 s2_6 392k
R2_6_20 na1_20 s2_6 255k
R2_6_21 a1_21 s2_6 280k
R2_6_22 a1_22 s2_6 1.07Meg
R2_6_23 a1_23 s2_6 255k
R2_6_24 na1_24 s2_6 165k
R2_6_25 a1_25 s2_6 604k
R2_6_26 a1_26 s2_6 976k
R2_6_27 a1_27 s2_6 523k
R2_6_28 a1_28 s2_6 1.1Meg
R2_6_29 na1_29 s2_6 237k
R2_6_30 na1_30 s2_6 698k
R2_6_31 na1_31 s2_6 475k
R2_6_32 a1_32 s2_6 316k
R2_6_33 na1_33 s2_6 127k
R2_6_35 na1_35 s2_6 340k
R2_6_36 a1_36 s2_6 301k
R2_6_37 a1_37 s2_6 931k
R2_6_38 a1_38 s2_6 392k
R2_6_39 na1_39 s2_6 309k
R2_6_40 na1_40 s2_6 147k
R2_6_41 na1_41 s2_6 221k
R2_6_42 na1_42 s2_6 226k
R2_6_43 a1_43 s2_6 715k
R2_6_46 na1_46 s2_6 1.37Meg
R2_6_47 a1_47 s2_6 124k
RB2_6 bn s2_6 432k
XI2_6 bI2_6 si2_6 vcc vee na2_6 LT1810
RBALI2_6 bI2_6 0 50k
RIA2_6 a2_6 si2_6 100k
RIF2_6 na2_6 si2_6 100k
CFRIF2_6 na2_6 si2_6 2p
XS2_7 bS2_7 s2_7 vcc veer a2_7 LT1810
RBALS2_7 bS2_7 0 5.87458k
RF2_7 a2_7 s2_7 100k
CFRF2_7 a2_7 s2_7 2p
R2_7_0 na1_0 s2_7 232k
R2_7_1 a1_1 s2_7 1.5Meg
R2_7_2 a1_2 s2_7 287k
R2_7_3 a1_3 s2_7 115k
R2_7_4 na1_4 s2_7 1.05Meg
R2_7_5 a1_5 s2_7 909k
R2_7_7 na1_7 s2_7 294k
R2_7_8 na1_8 s2_7 191k
R2_7_9 a1_9 s2_7 232k
R2_7_10 na1_10 s2_7 158k
R2_7_11 a1_11 s2_7 110k
R2_7_12 na1_12 s2_7 348k
R2_7_13 na1_13 s2_7 174k
R2_7_14 na1_14 s2_7 665k
R2_7_15 a1_15 s2_7 590k
R2_7_16 na1_16 s2_7 432k
R2_7_17 a1_17 s2_7 84.5k
R2_7_18 a1_18 s2_7 100k
R2_7_19 a1_19 s2_7 357k
R2_7_20 a1_20 s2_7 110k
R2_7_21 a1_21 s2_7 3.32Meg
R2_7_22 na1_22 s2_7 215k
R2_7_23 na1_23 s2_7 365k
R2_7_24 na1_24 s2_7 715k
R2_7_27 na1_27 s2_7 137k
R2_7_28 na1_28 s2_7 205k
R2_7_29 a1_29 s2_7 294k
R2_7_30 a1_30 s2_7 383k
R2_7_31 na1_31 s2_7 221k
R2_7_32 na1_32 s2_7 287k
R2_7_33 na1_33 s2_7 634k
R2_7_35 a1_35 s2_7 1.02Meg
R2_7_36 na1_36 s2_7 162k
R2_7_37 na1_37 s2_7 2.21Meg
R2_7_39 na1_39 s2_7 432k
R2_7_40 a1_40 s2_7 536k
R2_7_41 a1_41 s2_7 174k
R2_7_43 na1_43 s2_7 511k
R2_7_44 na1_44 s2_7 243k
R2_7_45 na1_45 s2_7 1.02Meg
R2_7_46 na1_46 s2_7 453k
R2_7_47 na1_47 s2_7 887k
XI2_7 bI2_7 si2_7 vcc vee na2_7 LT1810
RBALI2_7 bI2_7 0 50k
RIA2_7 a2_7 si2_7 100k
RIF2_7 na2_7 si2_7 100k
CFRIF2_7 na2_7 si2_7 2p
XS2_8 bS2_8 s2_8 vcc veer a2_8 LT1810
RBALS2_8 bS2_8 0 5.92096k
RF2_8 a2_8 s2_8 100k
CFRF2_8 a2_8 s2_8 2p
R2_8_0 na1_0 s2_8 255k
R2_8_2 a1_2 s2_8 280k
R2_8_3 na1_3 s2_8 1.21Meg
R2_8_4 na1_4 s2_8 1.78Meg
R2_8_5 a1_5 s2_8 287k
R2_8_6 a1_6 s2_8 294k
R2_8_7 na1_7 s2_8 237k
R2_8_8 na1_8 s2_8 130k
R2_8_9 a1_9 s2_8 1.74Meg
R2_8_10 na1_10 s2_8 1.69Meg
R2_8_11 a1_11 s2_8 523k
R2_8_12 na1_12 s2_8 499k
R2_8_13 a1_13 s2_8 357k
R2_8_14 a1_14 s2_8 392k
R2_8_15 na1_15 s2_8 221k
R2_8_16 a1_16 s2_8 2.32Meg
R2_8_17 na1_17 s2_8 143k
R2_8_18 a1_18 s2_8 215k
R2_8_19 a1_19 s2_8 1.27Meg
R2_8_20 na1_20 s2_8 475k
R2_8_21 na1_21 s2_8 432k
R2_8_23 a1_23 s2_8 619k
R2_8_24 na1_24 s2_8 453k
R2_8_25 a1_25 s2_8 453k
R2_8_26 a1_26 s2_8 255k
R2_8_27 a1_27 s2_8 162k
R2_8_28 na1_28 s2_8 787k
R2_8_29 a1_29 s2_8 215k
R2_8_30 a1_30 s2_8 191k
R2_8_31 na1_31 s2_8 102k
R2_8_32 a1_32 s2_8 309k
R2_8_33 a1_33 s2_8 205k
R2_8_34 na1_34 s2_8 976k
R2_8_35 a1_35 s2_8 1.69Meg
R2_8_36 na1_36 s2_8 196k
R2_8_37 na1_37 s2_8 196k
R2_8_39 a1_39 s2_8 324k
R2_8_40 a1_40 s2_8 232k
R2_8_41 a1_41 s2_8 294k
R2_8_42 a1_42 s2_8 174k
R2_8_43 na1_43 s2_8 1.1Meg
R2_8_44 na1_44 s2_8 316k
R2_8_45 a1_45 s2_8 1.33Meg
R2_8_46 a1_46 s2_8 64.9k
R2_8_47 a1_47 s2_8 357k
RB2_8 bn s2_8 422k
XI2_8 bI2_8 si2_8 vcc vee na2_8 LT1810
RBALI2_8 bI2_8 0 50k
RIA2_8 a2_8 si2_8 100k
RIF2_8 na2_8 si2_8 100k
CFRIF2_8 na2_8 si2_8 2p
XS2_9 bS2_9 s2_9 vcc veer a2_9 LT1810
RBALS2_9 bS2_9 0 7.19084k
RF2_9 a2_9 s2_9 100k
CFRF2_9 a2_9 s2_9 2p
R2_9_0 a1_0 s2_9 162k
R2_9_1 na1_1 s2_9 634k
R2_9_2 na1_2 s2_9 464k
R2_9_3 na1_3 s2_9 604k
R2_9_5 a1_5 s2_9 845k
R2_9_6 na1_6 s2_9 1.47Meg
R2_9_7 a1_7 s2_9 732k
R2_9_8 na1_8 s2_9 324k
R2_9_9 a1_9 s2_9 340k
R2_9_10 a1_10 s2_9 412k
R2_9_11 na1_11 s2_9 1.78Meg
R2_9_12 a1_12 s2_9 215k
R2_9_13 na1_13 s2_9 255k
R2_9_14 na1_14 s2_9 182k
R2_9_15 a1_15 s2_9 196k
R2_9_17 a1_17 s2_9 976k
R2_9_18 a1_18 s2_9 845k
R2_9_19 a1_19 s2_9 1.65Meg
R2_9_20 na1_20 s2_9 536k
R2_9_21 a1_21 s2_9 866k
R2_9_22 a1_22 s2_9 169k
R2_9_23 na1_23 s2_9 215k
R2_9_24 a1_24 s2_9 357k
R2_9_25 na1_25 s2_9 137k
R2_9_27 na1_27 s2_9 464k
R2_9_28 na1_28 s2_9 133k
R2_9_29 a1_29 s2_9 787k
R2_9_30 a1_30 s2_9 124k
R2_9_31 a1_31 s2_9 787k
R2_9_32 na1_32 s2_9 536k
R2_9_33 na1_33 s2_9 374k
R2_9_34 na1_34 s2_9 294k
R2_9_35 na1_35 s2_9 499k
R2_9_36 na1_36 s2_9 261k
R2_9_38 na1_38 s2_9 665k
R2_9_39 a1_39 s2_9 1.3Meg
R2_9_40 a1_40 s2_9 1.27Meg
R2_9_41 a1_41 s2_9 1.24Meg
R2_9_42 a1_42 s2_9 267k
R2_9_43 a1_43 s2_9 768k
R2_9_44 na1_44 s2_9 143k
R2_9_45 a1_45 s2_9 402k
R2_9_46 na1_46 s2_9 274k
R2_9_47 na1_47 s2_9 392k
RB2_9 bn s2_9 1.07Meg
XI2_9 bI2_9 si2_9 vcc vee na2_9 LT1810
RBALI2_9 bI2_9 0 50k
RIA2_9 a2_9 si2_9 100k
RIF2_9 na2_9 si2_9 100k
CFRIF2_9 na2_9 si2_9 2p
XS2_10 bS2_10 s2_10 vcc veer a2_10 LT1810
RBALS2_10 bS2_10 0 7.1806k
RF2_10 a2_10 s2_10 100k
CFRF2_10 a2_10 s2_10 2p
R2_10_0 a1_0 s2_10 182k
R2_10_1 na1_1 s2_10 105k
R2_10_2 na1_2 s2_10 294k
R2_10_4 na1_4 s2_10 402k
R2_10_6 a1_6 s2_10 1.69Meg
R2_10_7 na1_7 s2_10 825k
R2_10_9 na1_9 s2_10 1.4Meg
R2_10_10 na1_10 s2_10 422k
R2_10_11 na1_11 s2_10 392k
R2_10_12 na1_12 s2_10 324k
R2_10_13 na1_13 s2_10 133k
R2_10_14 na1_14 s2_10 1.87Meg
R2_10_15 a1_15 s2_10 102k
R2_10_16 a1_16 s2_10 1.58Meg
R2_10_17 na1_17 s2_10 2.43Meg
R2_10_18 na1_18 s2_10 287k
R2_10_19 na1_19 s2_10 200k
R2_10_20 na1_20 s2_10 1.58Meg
R2_10_21 a1_21 s2_10 634k
R2_10_22 na1_22 s2_10 1.91Meg
R2_10_23 a1_23 s2_10 237k
R2_10_24 a1_24 s2_10 1.27Meg
R2_10_26 na1_26 s2_10 232k
R2_10_27 na1_27 s2_10 806k
R2_10_28 a1_28 s2_10 1.5Meg
R2_10_29 a1_29 s2_10 249k
R2_10_30 na1_30 s2_10 261k
R2_10_31 na1_31 s2_10 576k
R2_10_32 na1_32 s2_10 2Meg
R2_10_33 na1_33 s2_10 127k
R2_10_34 a1_34 s2_10 137k
R2_10_35 na1_35 s2_10 392k
R2_10_36 a1_36 s2_10 1.27Meg
R2_10_37 a1_37 s2_10 634k
R2_10_38 na1_38 s2_10 301k
R2_10_39 na1_39 s2_10 845k
R2_10_42 na1_42 s2_10 118k
R2_10_43 a1_43 s2_10 432k
R2_10_44 a1_44 s2_10 324k
R2_10_45 na1_45 s2_10 464k
R2_10_46 a1_46 s2_10 365k
R2_10_47 a1_47 s2_10 576k
RB2_10 bn s2_10 768k
XI2_10 bI2_10 si2_10 vcc vee na2_10 LT1810
RBALI2_10 bI2_10 0 50k
RIA2_10 a2_10 si2_10 100k
RIF2_10 na2_10 si2_10 100k
CFRIF2_10 na2_10 si2_10 2p
XS2_11 bS2_11 s2_11 vcc veer a2_11 LT1810
RBALS2_11 bS2_11 0 7.44401k
RF2_11 a2_11 s2_11 100k
CFRF2_11 a2_11 s2_11 2p
R2_11_0 na1_0 s2_11 475k
R2_11_1 na1_1 s2_11 1.87Meg
R2_11_3 na1_3 s2_11 150k
R2_11_4 na1_4 s2_11 287k
R2_11_5 na1_5 s2_11 221k
R2_11_6 a1_6 s2_11 931k
R2_11_7 na1_7 s2_11 499k
R2_11_8 na1_8 s2_11 576k
R2_11_9 a1_9 s2_11 432k
R2_11_10 a1_10 s2_11 174k
R2_11_11 a1_11 s2_11 215k
R2_11_12 a1_12 s2_11 165k
R2_11_13 a1_13 s2_11 453k
R2_11_14 a1_14 s2_11 402k
R2_11_15 a1_15 s2_11 1.24Meg
R2_11_16 a1_16 s2_11 221k
R2_11_17 a1_17 s2_11 487k
R2_11_18 na1_18 s2_11 365k
R2_11_19 na1_19 s2_11 261k
R2_11_20 na1_20 s2_11 294k
R2_11_21 na1_21 s2_11 402k
R2_11_23 a1_23 s2_11 453k
R2_11_24 na1_24 s2_11 332k
R2_11_25 na1_25 s2_11 475k
R2_11_26 na1_26 s2_11 536k
R2_11_27 na1_27 s2_11 1.69Meg
R2_11_28 na1_28 s2_11 143k
R2_11_29 na1_29 s2_11 249k
R2_11_30 na1_30 s2_11 1.05Meg
R2_11_31 a1_31 s2_11 1.1Meg
R2_11_32 na1_32 s2_11 453k
R2_11_33 a1_33 s2_11 715k
R2_11_34 a1_34 s2_11 348k
R2_11_35 a1_35 s2_11 2.26Meg
R2_11_36 a1_36 s2_11 249k
R2_11_37 a1_37 s2_11 806k
R2_11_38 a1_38 s2_11 1.82Meg
R2_11_39 a1_39 s2_11 274k
R2_11_40 na1_40 s2_11 604k
R2_11_41 a1_41 s2_11 140k
R2_11_43 na1_43 s2_11 169k
R2_11_44 na1_44 s2_11 1.54Meg
R2_11_45 a1_45 s2_11 604k
R2_11_46 a1_46 s2_11 1.24Meg
R2_11_47 a1_47 s2_11 909k
RB2_11 bn s2_11 1.07Meg
XI2_11 bI2_11 si2_11 vcc vee na2_11 LT1810
RBALI2_11 bI2_11 0 50k
RIA2_11 a2_11 si2_11 100k
RIF2_11 na2_11 si2_11 100k
CFRIF2_11 na2_11 si2_11 2p
XS2_12 bS2_12 s2_12 vcc veer a2_12 LT1810
RBALS2_12 bS2_12 0 8.01189k
RF2_12 a2_12 s2_12 100k
CFRF2_12 a2_12 s2_12 2p
R2_12_0 a1_0 s2_12 301k
R2_12_1 a1_1 s2_12 499k
R2_12_2 na1_2 s2_12 909k
R2_12_3 na1_3 s2_12 255k
R2_12_4 a1_4 s2_12 931k
R2_12_5 a1_5 s2_12 464k
R2_12_6 a1_6 s2_12 2.1Meg
R2_12_7 a1_7 s2_12 1.82Meg
R2_12_8 na1_8 s2_12 732k
R2_12_9 na1_9 s2_12 953k
R2_12_10 a1_10 s2_12 301k
R2_12_11 na1_11 s2_12 1.37Meg
R2_12_12 a1_12 s2_12 383k
R2_12_13 a1_13 s2_12 1.4Meg
R2_12_14 a1_14 s2_12 511k
R2_12_15 na1_15 s2_12 787k
R2_12_16 a1_16 s2_12 169k
R2_12_17 na1_17 s2_12 232k
R2_12_18 na1_18 s2_12 301k
R2_12_19 na1_19 s2_12 649k
R2_12_20 na1_20 s2_12 169k
R2_12_21 na1_21 s2_12 196k
R2_12_22 na1_22 s2_12 205k
R2_12_23 a1_23 s2_12 121k
R2_12_24 na1_24 s2_12 536k
R2_12_25 a1_25 s2_12 274k
R2_12_26 a1_26 s2_12 634k
R2_12_27 na1_27 s2_12 825k
R2_12_28 a1_28 s2_12 1.37Meg
R2_12_29 a1_29 s2_12 649k
R2_12_31 na1_31 s2_12 215k
R2_12_33 na1_33 s2_12 162k
R2_12_34 na1_34 s2_12 562k
R2_12_35 a1_35 s2_12 274k
R2_12_36 na1_36 s2_12 422k
R2_12_37 na1_37 s2_12 1.96Meg
R2_12_38 na1_38 s2_12 340k
R2_12_39 na1_39 s2_12 464k
R2_12_40 a1_40 s2_12 2.05Meg
R2_12_42 a1_42 s2_12 340k
R2_12_43 a1_43 s2_12 1.37Meg
R2_12_44 na1_44 s2_12 698k
R2_12_45 na1_45 s2_12 681k
R2_12_47 a1_47 s2_12 200k
RB2_12 bn s2_12 931k
XI2_12 bI2_12 si2_12 vcc vee na2_12 LT1810
RBALI2_12 bI2_12 0 50k
RIA2_12 a2_12 si2_12 100k
RIF2_12 na2_12 si2_12 100k
CFRIF2_12 na2_12 si2_12 2p
XS2_13 bS2_13 s2_13 vcc veer a2_13 LT1810
RBALS2_13 bS2_13 0 7.00067k
RF2_13 a2_13 s2_13 100k
CFRF2_13 a2_13 s2_13 2p
R2_13_0 a1_0 s2_13 274k
R2_13_1 a1_1 s2_13 1.21Meg
R2_13_2 na1_2 s2_13 215k
R2_13_3 a1_3 s2_13 243k
R2_13_5 na1_5 s2_13 634k
R2_13_6 na1_6 s2_13 604k
R2_13_7 na1_7 s2_13 750k
R2_13_8 a1_8 s2_13 750k
R2_13_9 na1_9 s2_13 732k
R2_13_10 a1_10 s2_13 576k
R2_13_11 na1_11 s2_13 324k
R2_13_12 a1_12 s2_13 140k
R2_13_13 a1_13 s2_13 309k
R2_13_14 na1_14 s2_13 348k
R2_13_15 a1_15 s2_13 150k
R2_13_16 na1_16 s2_13 249k
R2_13_18 na1_18 s2_13 1.74Meg
R2_13_19 na1_19 s2_13 316k
R2_13_20 na1_20 s2_13 221k
R2_13_21 a1_21 s2_13 196k
R2_13_22 a1_22 s2_13 340k
R2_13_23 na1_23 s2_13 124k
R2_13_24 na1_24 s2_13 169k
R2_13_25 na1_25 s2_13 634k
R2_13_26 a1_26 s2_13 866k
R2_13_27 na1_27 s2_13 237k
R2_13_29 na1_29 s2_13 1.1Meg
R2_13_30 na1_30 s2_13 536k
R2_13_31 a1_31 s2_13 261k
R2_13_32 a1_32 s2_13 191k
R2_13_33 a1_33 s2_13 174k
R2_13_34 na1_34 s2_13 787k
R2_13_35 na1_35 s2_13 1.1Meg
R2_13_36 a1_36 s2_13 549k
R2_13_37 a1_37 s2_13 187k
R2_13_38 a1_38 s2_13 619k
R2_13_40 na1_40 s2_13 309k
R2_13_41 na1_41 s2_13 1.13Meg
R2_13_42 a1_42 s2_13 511k
R2_13_43 na1_43 s2_13 649k
R2_13_44 na1_44 s2_13 634k
R2_13_45 na1_45 s2_13 1.07Meg
R2_13_46 a1_46 s2_13 210k
R2_13_47 a1_47 s2_13 866k
RB2_13 bn s2_13 576k
XI2_13 bI2_13 si2_13 vcc vee na2_13 LT1810
RBALI2_13 bI2_13 0 50k
RIA2_13 a2_13 si2_13 100k
RIF2_13 na2_13 si2_13 100k
CFRIF2_13 na2_13 si2_13 2p
XS2_14 bS2_14 s2_14 vcc veer a2_14 LT1810
RBALS2_14 bS2_14 0 7.93413k
RF2_14 a2_14 s2_14 100k
CFRF2_14 a2_14 s2_14 2p
R2_14_0 na1_0 s2_14 825k
R2_14_1 a1_1 s2_14 374k
R2_14_2 na1_2 s2_14 1.69Meg
R2_14_4 na1_4 s2_14 1.69Meg
R2_14_5 na1_5 s2_14 169k
R2_14_6 na1_6 s2_14 348k
R2_14_7 na1_7 s2_14 332k
R2_14_8 na1_8 s2_14 340k
R2_14_9 a1_9 s2_14 536k
R2_14_10 a1_10 s2_14 340k
R2_14_11 a1_11 s2_14 1Meg
R2_14_12 a1_12 s2_14 487k
R2_14_13 a1_13 s2_14 169k
R2_14_14 na1_14 s2_14 549k
R2_14_15 na1_15 s2_14 562k
R2_14_16 a1_16 s2_14 453k
R2_14_17 a1_17 s2_14 200k
R2_14_18 na1_18 s2_14 232k
R2_14_19 na1_19 s2_14 348k
R2_14_20 a1_20 s2_14 154k
R2_14_22 na1_22 s2_14 1.43Meg
R2_14_23 na1_23 s2_14 1.27Meg
R2_14_24 na1_24 s2_14 768k
R2_14_25 a1_25 s2_14 154k
R2_14_26 a1_26 s2_14 523k
R2_14_27 a1_27 s2_14 1.54Meg
R2_14_28 a1_28 s2_14 1.33Meg
R2_14_29 a1_29 s2_14 1.21Meg
R2_14_30 a1_30 s2_14 226k
R2_14_31 na1_31 s2_14 475k
R2_14_32 na1_32 s2_14 365k
R2_14_33 na1_33 s2_14 953k
R2_14_34 a1_34 s2_14 294k
R2_14_35 na1_35 s2_14 196k
R2_14_36 a1_36 s2_14 1.21Meg
R2_14_37 na1_37 s2_14 143k
R2_14_38 a1_38 s2_14 787k
R2_14_39 na1_39 s2_14 931k
R2_14_40 a1_40 s2_14 1.87Meg
R2_14_41 a1_41 s2_14 2.67Meg
R2_14_42 a1_42 s2_14 324k
R2_14_43 a1_43 s2_14 392k
R2_14_44 a1_44 s2_14 487k
R2_14_45 na1_45 s2_14 340k
R2_14_46 a1_46 s2_14 365k
R2_14_47 a1_47 s2_14 2.15Meg
RB2_14 bn s2_14 1.24Meg
XI2_14 bI2_14 si2_14 vcc vee na2_14 LT1810
RBALI2_14 bI2_14 0 50k
RIA2_14 a2_14 si2_14 100k
RIF2_14 na2_14 si2_14 100k
CFRIF2_14 na2_14 si2_14 2p
XS2_15 bS2_15 s2_15 vcc veer a2_15 LT1810
RBALS2_15 bS2_15 0 7.33807k
RF2_15 a2_15 s2_15 100k
CFRF2_15 a2_15 s2_15 2p
R2_15_0 na1_0 s2_15 750k
R2_15_1 na1_1 s2_15 442k
R2_15_3 a1_3 s2_15 3.24Meg
R2_15_4 na1_4 s2_15 200k
R2_15_5 na1_5 s2_15 383k
R2_15_6 a1_6 s2_15 2.49Meg
R2_15_7 na1_7 s2_15 2.61Meg
R2_15_8 na1_8 s2_15 324k
R2_15_9 a1_9 s2_15 536k
R2_15_11 a1_11 s2_15 274k
R2_15_12 na1_12 s2_15 205k
R2_15_13 na1_13 s2_15 158k
R2_15_14 a1_14 s2_15 365k
R2_15_15 a1_15 s2_15 931k
R2_15_16 a1_16 s2_15 1.13Meg
R2_15_17 a1_17 s2_15 274k
R2_15_18 na1_18 s2_15 909k
R2_15_19 na1_19 s2_15 158k
R2_15_20 a1_20 s2_15 249k
R2_15_21 na1_21 s2_15 133k
R2_15_22 na1_22 s2_15 1.54Meg
R2_15_23 a1_23 s2_15 909k
R2_15_24 a1_24 s2_15 2Meg
R2_15_25 a1_25 s2_15 750k
R2_15_26 a1_26 s2_15 1.69Meg
R2_15_28 a1_28 s2_15 536k
R2_15_29 na1_29 s2_15 205k
R2_15_30 na1_30 s2_15 267k
R2_15_31 na1_31 s2_15 365k
R2_15_32 na1_32 s2_15 137k
R2_15_33 a1_33 s2_15 280k
R2_15_34 a1_34 s2_15 412k
R2_15_35 a1_35 s2_15 523k
R2_15_36 na1_36 s2_15 215k
R2_15_37 na1_37 s2_15 1.1Meg
R2_15_38 a1_38 s2_15 1.47Meg
R2_15_39 na1_39 s2_15 511k
R2_15_40 a1_40 s2_15 115k
R2_15_42 a1_42 s2_15 182k
R2_15_43 na1_43 s2_15 210k
R2_15_44 na1_44 s2_15 301k
R2_15_45 na1_45 s2_15 681k
R2_15_47 na1_47 s2_15 1.07Meg
RB2_15 bn s2_15 732k
XI2_15 bI2_15 si2_15 vcc vee na2_15 LT1810
RBALI2_15 bI2_15 0 50k
RIA2_15 a2_15 si2_15 100k
RIF2_15 na2_15 si2_15 100k
CFRIF2_15 na2_15 si2_15 2p
XS2_16 bS2_16 s2_16 vcc veer a2_16 LT1810
RBALS2_16 bS2_16 0 7.28637k
RF2_16 a2_16 s2_16 100k
CFRF2_16 a2_16 s2_16 2p
R2_16_0 a1_0 s2_16 1.69Meg
R2_16_1 na1_1 s2_16 392k
R2_16_2 a1_2 s2_16 422k
R2_16_3 a1_3 s2_16 205k
R2_16_4 na1_4 s2_16 267k
R2_16_5 na1_5 s2_16 499k
R2_16_6 a1_6 s2_16 732k
R2_16_7 na1_7 s2_16 536k
R2_16_8 a1_8 s2_16 953k
R2_16_9 na1_9 s2_16 698k
R2_16_10 na1_10 s2_16 221k
R2_16_11 a1_11 s2_16 1.82Meg
R2_16_12 na1_12 s2_16 357k
R2_16_13 a1_13 s2_16 549k
R2_16_14 a1_14 s2_16 392k
R2_16_15 a1_15 s2_16 162k
R2_16_16 a1_16 s2_16 1.5Meg
R2_16_17 a1_17 s2_16 133k
R2_16_18 na1_18 s2_16 909k
R2_16_20 a1_20 s2_16 255k
R2_16_21 a1_21 s2_16 432k
R2_16_22 na1_22 s2_16 2.87Meg
R2_16_23 a1_23 s2_16 392k
R2_16_24 na1_24 s2_16 357k
R2_16_25 a1_25 s2_16 1.96Meg
R2_16_26 na1_26 s2_16 255k
R2_16_27 a1_27 s2_16 200k
R2_16_28 na1_28 s2_16 953k
R2_16_29 na1_29 s2_16 105k
R2_16_30 na1_30 s2_16 95.3k
R2_16_31 a1_31 s2_16 1.07Meg
R2_16_32 na1_32 s2_16 523k
R2_16_33 a1_33 s2_16 931k
R2_16_34 a1_34 s2_16 1.02Meg
R2_16_35 a1_35 s2_16 475k
R2_16_36 a1_36 s2_16 340k
R2_16_37 na1_37 s2_16 750k
R2_16_38 a1_38 s2_16 412k
R2_16_40 a1_40 s2_16 357k
R2_16_41 a1_41 s2_16 549k
R2_16_42 a1_42 s2_16 169k
R2_16_43 na1_43 s2_16 1.02Meg
R2_16_44 a1_44 s2_16 287k
R2_16_45 na1_45 s2_16 698k
R2_16_46 a1_46 s2_16 768k
R2_16_47 a1_47 s2_16 590k
RB2_16 bn s2_16 475k
XI2_16 bI2_16 si2_16 vcc vee na2_16 LT1810
RBALI2_16 bI2_16 0 50k
RIA2_16 a2_16 si2_16 100k
RIF2_16 na2_16 si2_16 100k
CFRIF2_16 na2_16 si2_16 2p
XS2_17 bS2_17 s2_17 vcc veer a2_17 LT1810
RBALS2_17 bS2_17 0 7.84175k
RF2_17 a2_17 s2_17 100k
CFRF2_17 a2_17 s2_17 2p
R2_17_0 na1_0 s2_17 715k
R2_17_1 a1_1 s2_17 549k
R2_17_2 a1_2 s2_17 200k
R2_17_3 a1_3 s2_17 127k
R2_17_4 a1_4 s2_17 1.05Meg
R2_17_5 na1_5 s2_17 205k
R2_17_6 a1_6 s2_17 249k
R2_17_7 na1_7 s2_17 499k
R2_17_8 na1_8 s2_17 549k
R2_17_9 a1_9 s2_17 576k
R2_17_10 na1_10 s2_17 649k
R2_17_11 a1_11 s2_17 487k
R2_17_12 a1_12 s2_17 442k
R2_17_13 a1_13 s2_17 487k
R2_17_14 a1_14 s2_17 324k
R2_17_15 na1_15 s2_17 294k
R2_17_16 na1_16 s2_17 1.69Meg
R2_17_17 a1_17 s2_17 442k
R2_17_18 na1_18 s2_17 332k
R2_17_19 na1_19 s2_17 442k
R2_17_21 a1_21 s2_17 357k
R2_17_23 na1_23 s2_17 1.87Meg
R2_17_24 na1_24 s2_17 1.5Meg
R2_17_25 a1_25 s2_17 1.1Meg
R2_17_26 na1_26 s2_17 1.05Meg
R2_17_27 a1_27 s2_17 205k
R2_17_28 a1_28 s2_17 549k
R2_17_29 na1_29 s2_17 374k
R2_17_30 na1_30 s2_17 169k
R2_17_31 na1_31 s2_17 432k
R2_17_33 a1_33 s2_17 576k
R2_17_34 na1_34 s2_17 422k
R2_17_35 na1_35 s2_17 130k
R2_17_36 a1_36 s2_17 294k
R2_17_37 na1_37 s2_17 634k
R2_17_38 na1_38 s2_17 511k
R2_17_39 a1_39 s2_17 976k
R2_17_40 a1_40 s2_17 1.3Meg
R2_17_41 na1_41 s2_17 301k
R2_17_42 a1_42 s2_17 191k
R2_17_44 na1_44 s2_17 383k
R2_17_45 a1_45 s2_17 162k
R2_17_46 a1_46 s2_17 953k
R2_17_47 a1_47 s2_17 2Meg
RB2_17 bn s2_17 1.65Meg
XI2_17 bI2_17 si2_17 vcc vee na2_17 LT1810
RBALI2_17 bI2_17 0 50k
RIA2_17 a2_17 si2_17 100k
RIF2_17 na2_17 si2_17 100k
CFRIF2_17 na2_17 si2_17 2p
XS2_18 bS2_18 s2_18 vcc veer a2_18 LT1810
RBALS2_18 bS2_18 0 6.48264k
RF2_18 a2_18 s2_18 100k
CFRF2_18 a2_18 s2_18 2p
R2_18_0 na1_0 s2_18 255k
R2_18_1 na1_1 s2_18 158k
R2_18_2 na1_2 s2_18 1.13Meg
R2_18_3 na1_3 s2_18 215k
R2_18_4 a1_4 s2_18 267k
R2_18_5 na1_5 s2_18 267k
R2_18_6 a1_6 s2_18 226k
R2_18_7 a1_7 s2_18 1.43Meg
R2_18_8 a1_8 s2_18 147k
R2_18_10 a1_10 s2_18 487k
R2_18_11 na1_11 s2_18 196k
R2_18_12 na1_12 s2_18 649k
R2_18_13 a1_13 s2_18 523k
R2_18_14 na1_14 s2_18 287k
R2_18_15 na1_15 s2_18 511k
R2_18_16 a1_16 s2_18 1.13Meg
R2_18_17 a1_17 s2_18 365k
R2_18_18 a1_18 s2_18 249k
R2_18_19 a1_19 s2_18 182k
R2_18_20 a1_20 s2_18 1.37Meg
R2_18_21 na1_21 s2_18 340k
R2_18_22 na1_22 s2_18 1.27Meg
R2_18_23 na1_23 s2_18 294k
R2_18_26 a1_26 s2_18 887k
R2_18_27 a1_27 s2_18 182k
R2_18_28 na1_28 s2_18 464k
R2_18_29 a1_29 s2_18 187k
R2_18_30 na1_30 s2_18 332k
R2_18_31 na1_31 s2_18 402k
R2_18_32 a1_32 s2_18 649k
R2_18_33 na1_33 s2_18 1.18Meg
R2_18_34 a1_34 s2_18 301k
R2_18_35 na1_35 s2_18 221k
R2_18_36 na1_36 s2_18 1.02Meg
R2_18_37 na1_37 s2_18 412k
R2_18_38 a1_38 s2_18 267k
R2_18_39 na1_39 s2_18 205k
R2_18_40 na1_40 s2_18 105k
R2_18_41 na1_41 s2_18 187k
R2_18_42 na1_42 s2_18 274k
R2_18_43 na1_43 s2_18 1Meg
R2_18_45 a1_45 s2_18 162k
R2_18_47 na1_47 s2_18 226k
XI2_18 bI2_18 si2_18 vcc vee na2_18 LT1810
RBALI2_18 bI2_18 0 50k
RIA2_18 a2_18 si2_18 100k
RIF2_18 na2_18 si2_18 100k
CFRIF2_18 na2_18 si2_18 2p
XS2_19 bS2_19 s2_19 vcc veer a2_19 LT1810
RBALS2_19 bS2_19 0 6.3411k
RF2_19 a2_19 s2_19 100k
CFRF2_19 a2_19 s2_19 2p
R2_19_0 a1_0 s2_19 324k
R2_19_2 a1_2 s2_19 825k
R2_19_3 a1_3 s2_19 147k
R2_19_4 na1_4 s2_19 332k
R2_19_5 a1_5 s2_19 787k
R2_19_6 a1_6 s2_19 121k
R2_19_7 na1_7 s2_19 187k
R2_19_8 na1_8 s2_19 412k
R2_19_10 na1_10 s2_19 750k
R2_19_11 na1_11 s2_19 475k
R2_19_12 na1_12 s2_19 200k
R2_19_13 na1_13 s2_19 191k
R2_19_14 a1_14 s2_19 121k
R2_19_15 a1_15 s2_19 383k
R2_19_16 a1_16 s2_19 392k
R2_19_17 na1_17 s2_19 1.54Meg
R2_19_18 na1_18 s2_19 267k
R2_19_20 a1_20 s2_19 931k
R2_19_21 a1_21 s2_19 294k
R2_19_22 na1_22 s2_19 169k
R2_19_23 a1_23 s2_19 124k
R2_19_24 a1_24 s2_19 221k
R2_19_25 a1_25 s2_19 340k
R2_19_26 a1_26 s2_19 806k
R2_19_27 a1_27 s2_19 274k
R2_19_28 na1_28 s2_19 191k
R2_19_29 a1_29 s2_19 309k
R2_19_30 na1_30 s2_19 475k
R2_19_31 na1_31 s2_19 255k
R2_19_32 na1_32 s2_19 1.4Meg
R2_19_33 na1_33 s2_19 365k
R2_19_34 na1_34 s2_19 309k
R2_19_35 na1_35 s2_19 374k
R2_19_36 a1_36 s2_19 205k
R2_19_37 a1_37 s2_19 1.91Meg
R2_19_38 na1_38 s2_19 1.78Meg
R2_19_39 a1_39 s2_19 274k
R2_19_40 a1_40 s2_19 562k
R2_19_41 na1_41 s2_19 196k
R2_19_42 a1_42 s2_19 432k
R2_19_43 na1_43 s2_19 2Meg
R2_19_44 a1_44 s2_19 255k
R2_19_45 na1_45 s2_19 412k
R2_19_46 a1_46 s2_19 1.47Meg
R2_19_47 a1_47 s2_19 715k
RB2_19 bn s2_19 422k
XI2_19 bI2_19 si2_19 vcc vee na2_19 LT1810
RBALI2_19 bI2_19 0 50k
RIA2_19 a2_19 si2_19 100k
RIF2_19 na2_19 si2_19 100k
CFRIF2_19 na2_19 si2_19 2p
XS2_20 bS2_20 s2_20 vcc veer a2_20 LT1810
RBALS2_20 bS2_20 0 7.11118k
RF2_20 a2_20 s2_20 100k
CFRF2_20 a2_20 s2_20 2p
R2_20_0 na1_0 s2_20 787k
R2_20_1 na1_1 s2_20 1.15Meg
R2_20_3 na1_3 s2_20 154k
R2_20_4 a1_4 s2_20 237k
R2_20_5 a1_5 s2_20 1.24Meg
R2_20_6 na1_6 s2_20 150k
R2_20_7 na1_7 s2_20 232k
R2_20_8 na1_8 s2_20 453k
R2_20_9 a1_9 s2_20 261k
R2_20_10 na1_10 s2_20 825k
R2_20_11 a1_11 s2_20 442k
R2_20_13 a1_13 s2_20 196k
R2_20_14 a1_14 s2_20 1.27Meg
R2_20_16 na1_16 s2_20 1.74Meg
R2_20_17 na1_17 s2_20 412k
R2_20_18 na1_18 s2_20 340k
R2_20_19 a1_19 s2_20 140k
R2_20_20 na1_20 s2_20 1Meg
R2_20_21 a1_21 s2_20 576k
R2_20_22 na1_22 s2_20 866k
R2_20_23 na1_23 s2_20 191k
R2_20_24 na1_24 s2_20 422k
R2_20_25 na1_25 s2_20 332k
R2_20_26 a1_26 s2_20 715k
R2_20_27 a1_27 s2_20 113k
R2_20_28 na1_28 s2_20 2.49Meg
R2_20_29 na1_29 s2_20 374k
R2_20_30 a1_30 s2_20 1.62Meg
R2_20_31 a1_31 s2_20 340k
R2_20_32 a1_32 s2_20 453k
R2_20_33 a1_33 s2_20 332k
R2_20_34 a1_34 s2_20 549k
R2_20_35 na1_35 s2_20 649k
R2_20_36 a1_36 s2_20 453k
R2_20_37 a1_37 s2_20 73.2k
R2_20_38 na1_38 s2_20 1.96Meg
R2_20_39 a1_39 s2_20 499k
R2_20_40 na1_40 s2_20 274k
R2_20_41 a1_41 s2_20 649k
R2_20_42 a1_42 s2_20 2.87Meg
R2_20_44 a1_44 s2_20 402k
R2_20_45 na1_45 s2_20 845k
R2_20_46 a1_46 s2_20 249k
R2_20_47 na1_47 s2_20 169k
XI2_20 bI2_20 si2_20 vcc vee na2_20 LT1810
RBALI2_20 bI2_20 0 50k
RIA2_20 a2_20 si2_20 100k
RIF2_20 na2_20 si2_20 100k
CFRIF2_20 na2_20 si2_20 2p
XS2_21 bS2_21 s2_21 vcc veer a2_21 LT1810
RBALS2_21 bS2_21 0 9.9732k
RF2_21 a2_21 s2_21 100k
CFRF2_21 a2_21 s2_21 2p
R2_21_1 na1_1 s2_21 1.69Meg
R2_21_2 na1_2 s2_21 1.74Meg
R2_21_3 na1_3 s2_21 226k
R2_21_4 a1_4 s2_21 576k
R2_21_5 na1_5 s2_21 232k
R2_21_6 na1_6 s2_21 604k
R2_21_7 a1_7 s2_21 1.69Meg
R2_21_8 a1_8 s2_21 274k
R2_21_9 na1_9 s2_21 634k
R2_21_10 na1_10 s2_21 1.87Meg
R2_21_11 a1_11 s2_21 634k
R2_21_12 na1_12 s2_21 1.24Meg
R2_21_13 a1_13 s2_21 499k
R2_21_14 na1_14 s2_21 2Meg
R2_21_15 na1_15 s2_21 499k
R2_21_17 a1_17 s2_21 374k
R2_21_18 a1_18 s2_21 931k
R2_21_20 na1_20 s2_21 487k
R2_21_21 na1_21 s2_21 866k
R2_21_23 na1_23 s2_21 309k
R2_21_24 na1_24 s2_21 1.5Meg
R2_21_25 na1_25 s2_21 464k
R2_21_26 a1_26 s2_21 1.21Meg
R2_21_28 na1_28 s2_21 249k
R2_21_29 a1_29 s2_21 348k
R2_21_30 na1_30 s2_21 191k
R2_21_31 a1_31 s2_21 523k
R2_21_32 na1_32 s2_21 619k
R2_21_33 na1_33 s2_21 237k
R2_21_34 na1_34 s2_21 274k
R2_21_35 a1_35 s2_21 1.62Meg
R2_21_36 a1_36 s2_21 562k
R2_21_37 a1_37 s2_21 698k
R2_21_38 na1_38 s2_21 1.87Meg
R2_21_40 a1_40 s2_21 1.58Meg
R2_21_41 na1_41 s2_21 953k
R2_21_42 a1_42 s2_21 1.18Meg
R2_21_43 a1_43 s2_21 590k
R2_21_44 a1_44 s2_21 158k
R2_21_45 na1_45 s2_21 383k
R2_21_46 na1_46 s2_21 649k
R2_21_47 na1_47 s2_21 226k
RB2_21 bn s2_21 348k
XI2_21 bI2_21 si2_21 vcc vee na2_21 LT1810
RBALI2_21 bI2_21 0 50k
RIA2_21 a2_21 si2_21 100k
RIF2_21 na2_21 si2_21 100k
CFRIF2_21 na2_21 si2_21 2p
XS2_22 bS2_22 s2_22 vcc veer a2_22 LT1810
RBALS2_22 bS2_22 0 6.95712k
RF2_22 a2_22 s2_22 100k
CFRF2_22 a2_22 s2_22 2p
R2_22_0 na1_0 s2_22 536k
R2_22_1 a1_1 s2_22 1.62Meg
R2_22_2 na1_2 s2_22 845k
R2_22_3 a1_3 s2_22 1.13Meg
R2_22_4 a1_4 s2_22 130k
R2_22_5 a1_5 s2_22 845k
R2_22_6 a1_6 s2_22 1.58Meg
R2_22_8 na1_8 s2_22 1.24Meg
R2_22_9 na1_9 s2_22 487k
R2_22_10 na1_10 s2_22 392k
R2_22_11 a1_11 s2_22 147k
R2_22_12 a1_12 s2_22 768k
R2_22_13 na1_13 s2_22 412k
R2_22_14 na1_14 s2_22 150k
R2_22_15 a1_15 s2_22 124k
R2_22_16 na1_16 s2_22 154k
R2_22_18 na1_18 s2_22 1.62Meg
R2_22_19 na1_19 s2_22 232k
R2_22_20 na1_20 s2_22 191k
R2_22_22 a1_22 s2_22 511k
R2_22_23 a1_23 s2_22 110k
R2_22_24 na1_24 s2_22 634k
R2_22_25 na1_25 s2_22 374k
R2_22_26 a1_26 s2_22 1.07Meg
R2_22_28 na1_28 s2_22 453k
R2_22_29 na1_29 s2_22 147k
R2_22_30 na1_30 s2_22 324k
R2_22_32 na1_32 s2_22 187k
R2_22_33 a1_33 s2_22 442k
R2_22_35 na1_35 s2_22 309k
R2_22_36 a1_36 s2_22 105k
R2_22_37 a1_37 s2_22 1.74Meg
R2_22_39 a1_39 s2_22 237k
R2_22_40 na1_40 s2_22 787k
R2_22_41 na1_41 s2_22 316k
R2_22_42 na1_42 s2_22 187k
R2_22_43 na1_43 s2_22 825k
R2_22_44 a1_44 s2_22 332k
R2_22_45 a1_45 s2_22 909k
R2_22_47 na1_47 s2_22 267k
XI2_22 bI2_22 si2_22 vcc vee na2_22 LT1810
RBALI2_22 bI2_22 0 50k
RIA2_22 a2_22 si2_22 100k
RIF2_22 na2_22 si2_22 100k
CFRIF2_22 na2_22 si2_22 2p
XS2_23 bS2_23 s2_23 vcc veer a2_23 LT1810
RBALS2_23 bS2_23 0 6.68639k
RF2_23 a2_23 s2_23 100k
CFRF2_23 a2_23 s2_23 2p
R2_23_0 a1_0 s2_23 562k
R2_23_1 a1_1 s2_23 442k
R2_23_2 na1_2 s2_23 422k
R2_23_3 na1_3 s2_23 316k
R2_23_5 a1_5 s2_23 357k
R2_23_6 a1_6 s2_23 487k
R2_23_7 na1_7 s2_23 249k
R2_23_8 a1_8 s2_23 576k
R2_23_9 na1_9 s2_23 205k
R2_23_10 a1_10 s2_23 619k
R2_23_11 na1_11 s2_23 309k
R2_23_12 a1_12 s2_23 590k
R2_23_13 a1_13 s2_23 178k
R2_23_14 na1_14 s2_23 165k
R2_23_15 na1_15 s2_23 536k
R2_23_16 a1_16 s2_23 1.96Meg
R2_23_17 na1_17 s2_23 1.62Meg
R2_23_18 na1_18 s2_23 634k
R2_23_21 na1_21 s2_23 732k
R2_23_22 a1_22 s2_23 825k
R2_23_23 a1_23 s2_23 549k
R2_23_24 na1_24 s2_23 402k
R2_23_25 na1_25 s2_23 154k
R2_23_26 a1_26 s2_23 475k
R2_23_27 na1_27 s2_23 309k
R2_23_28 na1_28 s2_23 348k
R2_23_29 na1_29 s2_23 294k
R2_23_30 a1_30 s2_23 115k
R2_23_31 a1_31 s2_23 140k
R2_23_32 na1_32 s2_23 523k
R2_23_33 na1_33 s2_23 191k
R2_23_35 na1_35 s2_23 715k
R2_23_36 a1_36 s2_23 301k
R2_23_37 a1_37 s2_23 187k
R2_23_38 na1_38 s2_23 604k
R2_23_39 na1_39 s2_23 261k
R2_23_40 na1_40 s2_23 432k
R2_23_41 a1_41 s2_23 1.07Meg
R2_23_42 na1_42 s2_23 196k
R2_23_43 na1_43 s2_23 187k
R2_23_44 na1_44 s2_23 147k
R2_23_45 a1_45 s2_23 422k
R2_23_46 a1_46 s2_23 392k
R2_23_47 na1_47 s2_23 365k
XI2_23 bI2_23 si2_23 vcc vee na2_23 LT1810
RBALI2_23 bI2_23 0 50k
RIA2_23 a2_23 si2_23 100k
RIF2_23 na2_23 si2_23 100k
CFRIF2_23 na2_23 si2_23 2p
XS2_24 bS2_24 s2_24 vcc veer a2_24 LT1810
RBALS2_24 bS2_24 0 7.08301k
RF2_24 a2_24 s2_24 100k
CFRF2_24 a2_24 s2_24 2p
R2_24_0 a1_0 s2_24 523k
R2_24_1 a1_1 s2_24 619k
R2_24_2 na1_2 s2_24 1.78Meg
R2_24_5 na1_5 s2_24 511k
R2_24_6 na1_6 s2_24 619k
R2_24_7 na1_7 s2_24 340k
R2_24_8 na1_8 s2_24 243k
R2_24_9 na1_9 s2_24 215k
R2_24_10 a1_10 s2_24 316k
R2_24_11 a1_11 s2_24 887k
R2_24_12 a1_12 s2_24 196k
R2_24_13 na1_13 s2_24 294k
R2_24_14 a1_14 s2_24 590k
R2_24_15 a1_15 s2_24 1.78Meg
R2_24_16 na1_16 s2_24 422k
R2_24_17 a1_17 s2_24 182k
R2_24_18 na1_18 s2_24 340k
R2_24_19 a1_19 s2_24 332k
R2_24_20 a1_20 s2_24 750k
R2_24_21 na1_21 s2_24 536k
R2_24_23 na1_23 s2_24 215k
R2_24_24 a1_24 s2_24 576k
R2_24_25 na1_25 s2_24 909k
R2_24_26 na1_26 s2_24 1.62Meg
R2_24_27 na1_27 s2_24 1.4Meg
R2_24_28 na1_28 s2_24 412k
R2_24_30 a1_30 s2_24 105k
R2_24_31 na1_31 s2_24 255k
R2_24_32 na1_32 s2_24 261k
R2_24_33 a1_33 s2_24 453k
R2_24_34 na1_34 s2_24 215k
R2_24_35 a1_35 s2_24 1.15Meg
R2_24_36 na1_36 s2_24 169k
R2_24_37 na1_37 s2_24 549k
R2_24_38 na1_38 s2_24 357k
R2_24_39 a1_39 s2_24 562k
R2_24_40 a1_40 s2_24 412k
R2_24_41 a1_41 s2_24 150k
R2_24_42 na1_42 s2_24 324k
R2_24_43 na1_43 s2_24 221k
R2_24_44 na1_44 s2_24 165k
R2_24_45 a1_45 s2_24 1.82Meg
R2_24_46 a1_46 s2_24 1.07Meg
R2_24_47 na1_47 s2_24 187k
RB2_24 bn s2_24 634k
XI2_24 bI2_24 si2_24 vcc vee na2_24 LT1810
RBALI2_24 bI2_24 0 50k
RIA2_24 a2_24 si2_24 100k
RIF2_24 na2_24 si2_24 100k
CFRIF2_24 na2_24 si2_24 2p
XS2_25 bS2_25 s2_25 vcc veer a2_25 LT1810
RBALS2_25 bS2_25 0 7.76271k
RF2_25 a2_25 s2_25 100k
CFRF2_25 a2_25 s2_25 2p
R2_25_0 na1_0 s2_25 487k
R2_25_1 na1_1 s2_25 1.21Meg
R2_25_2 na1_2 s2_25 649k
R2_25_3 a1_3 s2_25 634k
R2_25_4 a1_4 s2_25 887k
R2_25_5 na1_5 s2_25 523k
R2_25_6 na1_6 s2_25 422k
R2_25_7 na1_7 s2_25 182k
R2_25_8 a1_8 s2_25 274k
R2_25_9 na1_9 s2_25 340k
R2_25_10 a1_10 s2_25 261k
R2_25_11 na1_11 s2_25 191k
R2_25_12 na1_12 s2_25 732k
R2_25_16 na1_16 s2_25 324k
R2_25_18 a1_18 s2_25 1.21Meg
R2_25_19 a1_19 s2_25 243k
R2_25_20 a1_20 s2_25 866k
R2_25_21 a1_21 s2_25 191k
R2_25_23 a1_23 s2_25 348k
R2_25_24 na1_24 s2_25 487k
R2_25_25 na1_25 s2_25 232k
R2_25_26 na1_26 s2_25 158k
R2_25_27 na1_27 s2_25 309k
R2_25_28 a1_28 s2_25 280k
R2_25_29 a1_29 s2_25 523k
R2_25_30 na1_30 s2_25 511k
R2_25_31 a1_31 s2_25 178k
R2_25_33 na1_33 s2_25 1.62Meg
R2_25_34 na1_34 s2_25 464k
R2_25_36 a1_36 s2_25 316k
R2_25_37 a1_37 s2_25 182k
R2_25_38 a1_38 s2_25 866k
R2_25_39 a1_39 s2_25 348k
R2_25_40 a1_40 s2_25 267k
R2_25_41 na1_41 s2_25 442k
R2_25_42 na1_42 s2_25 147k
R2_25_43 na1_43 s2_25 1.02Meg
R2_25_44 a1_44 s2_25 324k
R2_25_45 a1_45 s2_25 324k
R2_25_46 na1_46 s2_25 806k
R2_25_47 na1_47 s2_25 2.67Meg
RB2_25 bp s2_25 634k
XI2_25 bI2_25 si2_25 vcc vee na2_25 LT1810
RBALI2_25 bI2_25 0 50k
RIA2_25 a2_25 si2_25 100k
RIF2_25 na2_25 si2_25 100k
CFRIF2_25 na2_25 si2_25 2p
XS2_26 bS2_26 s2_26 vcc veer a2_26 LT1810
RBALS2_26 bS2_26 0 7.75711k
RF2_26 a2_26 s2_26 100k
CFRF2_26 a2_26 s2_26 2p
R2_26_0 a1_0 s2_26 768k
R2_26_1 na1_1 s2_26 1.54Meg
R2_26_2 na1_2 s2_26 1.1Meg
R2_26_3 na1_3 s2_26 931k
R2_26_4 na1_4 s2_26 1.47Meg
R2_26_5 na1_5 s2_26 374k
R2_26_6 na1_6 s2_26 2.15Meg
R2_26_7 na1_7 s2_26 422k
R2_26_8 na1_8 s2_26 1Meg
R2_26_10 na1_10 s2_26 604k
R2_26_11 na1_11 s2_26 340k
R2_26_12 na1_12 s2_26 1.1Meg
R2_26_13 na1_13 s2_26 768k
R2_26_14 a1_14 s2_26 536k
R2_26_15 a1_15 s2_26 309k
R2_26_18 a1_18 s2_26 165k
R2_26_19 a1_19 s2_26 332k
R2_26_20 na1_20 s2_26 1.62Meg
R2_26_21 a1_21 s2_26 422k
R2_26_22 na1_22 s2_26 619k
R2_26_23 na1_23 s2_26 140k
R2_26_24 na1_24 s2_26 261k
R2_26_25 a1_25 s2_26 287k
R2_26_26 na1_26 s2_26 200k
R2_26_27 na1_27 s2_26 158k
R2_26_28 na1_28 s2_26 845k
R2_26_29 a1_29 s2_26 1.96Meg
R2_26_30 na1_30 s2_26 249k
R2_26_31 a1_31 s2_26 165k
R2_26_32 a1_32 s2_26 210k
R2_26_33 a1_33 s2_26 768k
R2_26_34 a1_34 s2_26 1.1Meg
R2_26_35 a1_35 s2_26 187k
R2_26_36 na1_36 s2_26 511k
R2_26_37 a1_37 s2_26 649k
R2_26_38 na1_38 s2_26 2.37Meg
R2_26_39 na1_39 s2_26 562k
R2_26_40 a1_40 s2_26 332k
R2_26_41 na1_41 s2_26 976k
R2_26_42 na1_42 s2_26 154k
R2_26_43 a1_43 s2_26 1.05Meg
R2_26_44 a1_44 s2_26 174k
R2_26_45 na1_45 s2_26 232k
R2_26_46 a1_46 s2_26 619k
R2_26_47 a1_47 s2_26 576k
RB2_26 bn s2_26 576k
XI2_26 bI2_26 si2_26 vcc vee na2_26 LT1810
RBALI2_26 bI2_26 0 50k
RIA2_26 a2_26 si2_26 100k
RIF2_26 na2_26 si2_26 100k
CFRIF2_26 na2_26 si2_26 2p
XS2_27 bS2_27 s2_27 vcc veer a2_27 LT1810
RBALS2_27 bS2_27 0 7.70833k
RF2_27 a2_27 s2_27 100k
CFRF2_27 a2_27 s2_27 2p
R2_27_0 na1_0 s2_27 280k
R2_27_1 a1_1 s2_27 340k
R2_27_5 na1_5 s2_27 1.27Meg
R2_27_6 na1_6 s2_27 274k
R2_27_7 a1_7 s2_27 909k
R2_27_8 na1_8 s2_27 562k
R2_27_9 a1_9 s2_27 866k
R2_27_10 a1_10 s2_27 442k
R2_27_11 na1_11 s2_27 169k
R2_27_12 na1_12 s2_27 1.43Meg
R2_27_13 a1_13 s2_27 432k
R2_27_14 na1_14 s2_27 1.07Meg
R2_27_15 a1_15 s2_27 249k
R2_27_16 a1_16 s2_27 280k
R2_27_17 na1_17 s2_27 178k
R2_27_18 na1_18 s2_27 523k
R2_27_19 a1_19 s2_27 1.69Meg
R2_27_20 na1_20 s2_27 316k
R2_27_21 a1_21 s2_27 274k
R2_27_22 na1_22 s2_27 1.07Meg
R2_27_23 na1_23 s2_27 243k
R2_27_24 na1_24 s2_27 464k
R2_27_27 na1_27 s2_27 316k
R2_27_28 na1_28 s2_27 232k
R2_27_29 a1_29 s2_27 243k
R2_27_30 a1_30 s2_27 562k
R2_27_31 a1_31 s2_27 301k
R2_27_32 a1_32 s2_27 750k
R2_27_33 na1_33 s2_27 487k
R2_27_34 na1_34 s2_27 576k
R2_27_35 na1_35 s2_27 348k
R2_27_36 a1_36 s2_27 287k
R2_27_37 a1_37 s2_27 1.4Meg
R2_27_38 na1_38 s2_27 562k
R2_27_39 a1_39 s2_27 249k
R2_27_40 na1_40 s2_27 261k
R2_27_41 na1_41 s2_27 124k
R2_27_42 na1_42 s2_27 432k
R2_27_43 na1_43 s2_27 169k
R2_27_44 a1_44 s2_27 165k
R2_27_45 na1_45 s2_27 1.24Meg
RB2_27 bp s2_27 825k
XI2_27 bI2_27 si2_27 vcc vee na2_27 LT1810
RBALI2_27 bI2_27 0 50k
RIA2_27 a2_27 si2_27 100k
RIF2_27 na2_27 si2_27 100k
CFRIF2_27 na2_27 si2_27 2p
XS2_28 bS2_28 s2_28 vcc veer a2_28 LT1810
RBALS2_28 bS2_28 0 6.65448k
RF2_28 a2_28 s2_28 100k
CFRF2_28 a2_28 s2_28 2p
R2_28_0 a1_0 s2_28 1.02Meg
R2_28_1 na1_1 s2_28 115k
R2_28_2 a1_2 s2_28 309k
R2_28_3 a1_3 s2_28 976k
R2_28_4 a1_4 s2_28 357k
R2_28_5 a1_5 s2_28 332k
R2_28_6 na1_6 s2_28 634k
R2_28_7 a1_7 s2_28 432k
R2_28_8 na1_8 s2_28 1.4Meg
R2_28_9 na1_9 s2_28 576k
R2_28_10 na1_10 s2_28 121k
R2_28_11 a1_11 s2_28 316k
R2_28_12 na1_12 s2_28 182k
R2_28_13 a1_13 s2_28 750k
R2_28_15 a1_15 s2_28 287k
R2_28_16 na1_16 s2_28 1.87Meg
R2_28_17 na1_17 s2_28 143k
R2_28_19 na1_19 s2_28 1.5Meg
R2_28_20 a1_20 s2_28 549k
R2_28_21 a1_21 s2_28 402k
R2_28_22 na1_22 s2_28 158k
R2_28_23 na1_23 s2_28 267k
R2_28_24 a1_24 s2_28 976k
R2_28_25 na1_25 s2_28 1.21Meg
R2_28_26 na1_26 s2_28 576k
R2_28_27 na1_27 s2_28 845k
R2_28_28 a1_28 s2_28 442k
R2_28_29 na1_29 s2_28 357k
R2_28_30 na1_30 s2_28 165k
R2_28_31 na1_31 s2_28 280k
R2_28_32 a1_32 s2_28 332k
R2_28_33 na1_33 s2_28 332k
R2_28_34 a1_34 s2_28 309k
R2_28_35 a1_35 s2_28 732k
R2_28_36 na1_36 s2_28 340k
R2_28_37 na1_37 s2_28 365k
R2_28_38 a1_38 s2_28 232k
R2_28_39 a1_39 s2_28 392k
R2_28_40 na1_40 s2_28 976k
R2_28_41 na1_41 s2_28 143k
R2_28_42 a1_42 s2_28 453k
R2_28_43 a1_43 s2_28 150k
R2_28_44 na1_44 s2_28 191k
R2_28_45 a1_45 s2_28 2.15Meg
R2_28_46 a1_46 s2_28 1.15Meg
R2_28_47 na1_47 s2_28 665k
RB2_28 bn s2_28 442k
XI2_28 bI2_28 si2_28 vcc vee na2_28 LT1810
RBALI2_28 bI2_28 0 50k
RIA2_28 a2_28 si2_28 100k
RIF2_28 na2_28 si2_28 100k
CFRIF2_28 na2_28 si2_28 2p
XS2_29 bS2_29 s2_29 vcc veer a2_29 LT1810
RBALS2_29 bS2_29 0 7.11438k
RF2_29 a2_29 s2_29 100k
CFRF2_29 a2_29 s2_29 2p
R2_29_0 a1_0 s2_29 619k
R2_29_1 na1_1 s2_29 732k
R2_29_2 na1_2 s2_29 562k
R2_29_3 na1_3 s2_29 237k
R2_29_4 a1_4 s2_29 232k
R2_29_5 a1_5 s2_29 215k
R2_29_6 na1_6 s2_29 340k
R2_29_7 a1_7 s2_29 210k
R2_29_8 a1_8 s2_29 887k
R2_29_10 na1_10 s2_29 1.96Meg
R2_29_11 na1_11 s2_29 562k
R2_29_12 na1_12 s2_29 590k
R2_29_13 a1_13 s2_29 383k
R2_29_14 na1_14 s2_29 499k
R2_29_15 a1_15 s2_29 226k
R2_29_16 na1_16 s2_29 174k
R2_29_17 na1_17 s2_29 237k
R2_29_18 a1_18 s2_29 732k
R2_29_19 na1_19 s2_29 1.78Meg
R2_29_20 na1_20 s2_29 309k
R2_29_22 a1_22 s2_29 196k
R2_29_23 na1_23 s2_29 178k
R2_29_24 a1_24 s2_29 348k
R2_29_25 na1_25 s2_29 340k
R2_29_26 na1_26 s2_29 412k
R2_29_27 na1_27 s2_29 698k
R2_29_28 a1_28 s2_29 619k
R2_29_29 na1_29 s2_29 357k
R2_29_30 a1_30 s2_29 750k
R2_29_31 na1_31 s2_29 2.67Meg
R2_29_32 na1_32 s2_29 196k
R2_29_33 a1_33 s2_29 249k
R2_29_34 a1_34 s2_29 442k
R2_29_35 na1_35 s2_29 280k
R2_29_36 na1_36 s2_29 1.3Meg
R2_29_38 na1_38 s2_29 619k
R2_29_39 a1_39 s2_29 1.3Meg
R2_29_40 a1_40 s2_29 1.47Meg
R2_29_41 a1_41 s2_29 182k
R2_29_42 a1_42 s2_29 162k
R2_29_43 a1_43 s2_29 1.13Meg
R2_29_44 a1_44 s2_29 267k
R2_29_45 na1_45 s2_29 475k
R2_29_46 a1_46 s2_29 127k
R2_29_47 na1_47 s2_29 432k
RB2_29 bn s2_29 576k
XI2_29 bI2_29 si2_29 vcc vee na2_29 LT1810
RBALI2_29 bI2_29 0 50k
RIA2_29 a2_29 si2_29 100k
RIF2_29 na2_29 si2_29 100k
CFRIF2_29 na2_29 si2_29 2p
XS2_30 bS2_30 s2_30 vcc veer a2_30 LT1810
RBALS2_30 bS2_30 0 6.88004k
RF2_30 a2_30 s2_30 100k
CFRF2_30 a2_30 s2_30 2p
R2_30_0 a1_0 s2_30 243k
R2_30_1 na1_1 s2_30 210k
R2_30_2 na1_2 s2_30 309k
R2_30_3 a1_3 s2_30 90.9k
R2_30_4 a1_4 s2_30 681k
R2_30_5 na1_5 s2_30 523k
R2_30_6 a1_6 s2_30 549k
R2_30_7 a1_7 s2_30 1.3Meg
R2_30_8 a1_8 s2_30 1.18Meg
R2_30_9 a1_9 s2_30 274k
R2_30_10 na1_10 s2_30 301k
R2_30_11 a1_11 s2_30 147k
R2_30_13 na1_13 s2_30 453k
R2_30_14 na1_14 s2_30 169k
R2_30_15 a1_15 s2_30 1.13Meg
R2_30_16 na1_16 s2_30 499k
R2_30_17 a1_17 s2_30 294k
R2_30_18 a1_18 s2_30 590k
R2_30_19 na1_19 s2_30 232k
R2_30_20 na1_20 s2_30 2.15Meg
R2_30_21 na1_21 s2_30 1.24Meg
R2_30_22 na1_22 s2_30 1Meg
R2_30_23 a1_23 s2_30 412k
R2_30_24 a1_24 s2_30 124k
R2_30_25 na1_25 s2_30 174k
R2_30_26 na1_26 s2_30 845k
R2_30_27 a1_27 s2_30 243k
R2_30_28 na1_28 s2_30 187k
R2_30_29 a1_29 s2_30 909k
R2_30_30 a1_30 s2_30 634k
R2_30_31 na1_31 s2_30 1.62Meg
R2_30_32 na1_32 s2_30 205k
R2_30_33 a1_33 s2_30 196k
R2_30_34 na1_34 s2_30 499k
R2_30_35 a1_35 s2_30 232k
R2_30_37 a1_37 s2_30 392k
R2_30_38 a1_38 s2_30 511k
R2_30_39 a1_39 s2_30 698k
R2_30_40 a1_40 s2_30 953k
R2_30_41 na1_41 s2_30 221k
R2_30_42 na1_42 s2_30 392k
R2_30_43 na1_43 s2_30 316k
R2_30_44 na1_44 s2_30 453k
R2_30_45 na1_45 s2_30 422k
R2_30_47 na1_47 s2_30 1.5Meg
XI2_30 bI2_30 si2_30 vcc vee na2_30 LT1810
RBALI2_30 bI2_30 0 50k
RIA2_30 a2_30 si2_30 100k
RIF2_30 na2_30 si2_30 100k
CFRIF2_30 na2_30 si2_30 2p
XS2_31 bS2_31 s2_31 vcc veer a2_31 LT1810
RBALS2_31 bS2_31 0 6.63427k
RF2_31 a2_31 s2_31 100k
CFRF2_31 a2_31 s2_31 2p
R2_31_0 a1_0 s2_31 287k
R2_31_2 a1_2 s2_31 604k
R2_31_4 na1_4 s2_31 536k
R2_31_5 a1_5 s2_31 191k
R2_31_6 na1_6 s2_31 383k
R2_31_7 na1_7 s2_31 453k
R2_31_8 na1_8 s2_31 604k
R2_31_9 a1_9 s2_31 845k
R2_31_10 na1_10 s2_31 453k
R2_31_11 na1_11 s2_31 215k
R2_31_12 a1_12 s2_31 365k
R2_31_13 na1_13 s2_31 562k
R2_31_14 na1_14 s2_31 147k
R2_31_15 na1_15 s2_31 649k
R2_31_16 na1_16 s2_31 140k
R2_31_17 na1_17 s2_31 215k
R2_31_18 a1_18 s2_31 261k
R2_31_19 a1_19 s2_31 267k
R2_31_20 na1_20 s2_31 332k
R2_31_21 a1_21 s2_31 2.21Meg
R2_31_22 a1_22 s2_31 1.4Meg
R2_31_23 na1_23 s2_31 154k
R2_31_24 a1_24 s2_31 2.21Meg
R2_31_25 a1_25 s2_31 169k
R2_31_26 na1_26 s2_31 392k
R2_31_27 na1_27 s2_31 332k
R2_31_28 na1_28 s2_31 909k
R2_31_29 a1_29 s2_31 309k
R2_31_31 na1_31 s2_31 732k
R2_31_32 a1_32 s2_31 140k
R2_31_33 a1_33 s2_31 499k
R2_31_34 na1_34 s2_31 1.69Meg
R2_31_35 na1_35 s2_31 392k
R2_31_36 na1_36 s2_31 274k
R2_31_37 a1_37 s2_31 95.3k
R2_31_38 a1_38 s2_31 2.15Meg
R2_31_39 a1_39 s2_31 365k
R2_31_40 na1_40 s2_31 267k
R2_31_41 na1_41 s2_31 453k
R2_31_42 na1_42 s2_31 267k
R2_31_43 a1_43 s2_31 866k
R2_31_44 na1_44 s2_31 143k
R2_31_45 a1_45 s2_31 787k
R2_31_46 a1_46 s2_31 1.15Meg
R2_31_47 na1_47 s2_31 604k
RB2_31 bn s2_31 464k
XI2_31 bI2_31 si2_31 vcc vee na2_31 LT1810
RBALI2_31 bI2_31 0 50k
RIA2_31 a2_31 si2_31 100k
RIF2_31 na2_31 si2_31 100k
CFRIF2_31 na2_31 si2_31 2p
* ---- stage 3: 32 -> 24 (hidden, single-supply ReLU)
XS3_0 bS3_0 s3_0 vcc veer a3_0 LT1810
RBALS3_0 bS3_0 0 10.7104k
RF3_0 a3_0 s3_0 100k
CFRF3_0 a3_0 s3_0 2p
R3_0_0 na2_0 s3_0 105k
R3_0_1 a2_1 s3_0 523k
R3_0_2 na2_2 s3_0 649k
R3_0_3 a2_3 s3_0 1.62Meg
R3_0_4 na2_4 s3_0 324k
R3_0_5 a2_5 s3_0 422k
R3_0_6 a2_6 s3_0 634k
R3_0_7 a2_7 s3_0 165k
R3_0_8 na2_8 s3_0 732k
R3_0_9 na2_9 s3_0 205k
R3_0_11 na2_11 s3_0 787k
R3_0_12 na2_12 s3_0 249k
R3_0_13 na2_13 s3_0 422k
R3_0_14 na2_14 s3_0 453k
R3_0_16 a2_16 s3_0 316k
R3_0_17 a2_17 s3_0 1.91Meg
R3_0_18 a2_18 s3_0 536k
R3_0_19 na2_19 s3_0 115k
R3_0_20 na2_20 s3_0 255k
R3_0_22 a2_22 s3_0 576k
R3_0_24 a2_24 s3_0 1.47Meg
R3_0_25 na2_25 s3_0 316k
R3_0_26 na2_26 s3_0 392k
R3_0_27 a2_27 s3_0 422k
R3_0_28 a2_28 s3_0 442k
R3_0_29 na2_29 s3_0 294k
R3_0_30 a2_30 s3_0 1.5Meg
R3_0_31 na2_31 s3_0 210k
RB3_0 bn s3_0 1.24Meg
XI3_0 bI3_0 si3_0 vcc vee na3_0 LT1810
RBALI3_0 bI3_0 0 50k
RIA3_0 a3_0 si3_0 100k
RIF3_0 na3_0 si3_0 100k
CFRIF3_0 na3_0 si3_0 2p
XS3_1 bS3_1 s3_1 vcc veer a3_1 LT1810
RBALS3_1 bS3_1 0 8.73746k
RF3_1 a3_1 s3_1 100k
CFRF3_1 a3_1 s3_1 2p
R3_1_0 na2_0 s3_1 976k
R3_1_1 na2_1 s3_1 1.21Meg
R3_1_2 a2_2 s3_1 499k
R3_1_4 na2_4 s3_1 196k
R3_1_5 na2_5 s3_1 750k
R3_1_6 na2_6 s3_1 1.37Meg
R3_1_7 a2_7 s3_1 182k
R3_1_8 na2_8 s3_1 365k
R3_1_9 a2_9 s3_1 95.3k
R3_1_10 a2_10 s3_1 1.62Meg
R3_1_11 na2_11 s3_1 422k
R3_1_12 na2_12 s3_1 97.6k
R3_1_13 na2_13 s3_1 249k
R3_1_14 na2_14 s3_1 174k
R3_1_15 na2_15 s3_1 715k
R3_1_16 a2_16 s3_1 215k
R3_1_18 na2_18 s3_1 432k
R3_1_19 na2_19 s3_1 140k
R3_1_20 a2_20 s3_1 226k
R3_1_21 na2_21 s3_1 634k
R3_1_22 a2_22 s3_1 402k
R3_1_23 a2_23 s3_1 1.82Meg
R3_1_25 a2_25 s3_1 1.05Meg
R3_1_26 a2_26 s3_1 374k
R3_1_27 a2_27 s3_1 649k
R3_1_28 a2_28 s3_1 787k
R3_1_29 a2_29 s3_1 121k
R3_1_30 a2_30 s3_1 100k
R3_1_31 a2_31 s3_1 698k
RB3_1 bp s3_1 976k
XI3_1 bI3_1 si3_1 vcc vee na3_1 LT1810
RBALI3_1 bI3_1 0 50k
RIA3_1 a3_1 si3_1 100k
RIF3_1 na3_1 si3_1 100k
CFRIF3_1 na3_1 si3_1 2p
XS3_2 bS3_2 s3_2 vcc veer a3_2 LT1810
RBALS3_2 bS3_2 0 8.91462k
RF3_2 a3_2 s3_2 100k
CFRF3_2 a3_2 s3_2 2p
R3_2_0 na2_0 s3_2 301k
R3_2_1 na2_1 s3_2 422k
R3_2_2 na2_2 s3_2 100k
R3_2_3 a2_3 s3_2 274k
R3_2_5 na2_5 s3_2 226k
R3_2_7 a2_7 s3_2 178k
R3_2_8 na2_8 s3_2 133k
R3_2_9 na2_9 s3_2 210k
R3_2_11 na2_11 s3_2 210k
R3_2_12 a2_12 s3_2 422k
R3_2_14 na2_14 s3_2 845k
R3_2_15 a2_15 s3_2 768k
R3_2_16 na2_16 s3_2 374k
R3_2_17 a2_17 s3_2 158k
R3_2_18 na2_18 s3_2 1.33Meg
R3_2_19 a2_19 s3_2 649k
R3_2_20 na2_20 s3_2 1.05Meg
R3_2_21 a2_21 s3_2 267k
R3_2_22 a2_22 s3_2 475k
R3_2_23 na2_23 s3_2 255k
R3_2_24 na2_24 s3_2 196k
R3_2_26 na2_26 s3_2 383k
R3_2_27 a2_27 s3_2 301k
R3_2_28 a2_28 s3_2 113k
R3_2_29 a2_29 s3_2 158k
R3_2_30 a2_30 s3_2 887k
R3_2_31 na2_31 s3_2 3.83Meg
RB3_2 bn s3_2 787k
XI3_2 bI3_2 si3_2 vcc vee na3_2 LT1810
RBALI3_2 bI3_2 0 50k
RIA3_2 a3_2 si3_2 100k
RIF3_2 na3_2 si3_2 100k
CFRIF3_2 na3_2 si3_2 2p
XS3_3 bS3_3 s3_3 vcc veer a3_3 LT1810
RBALS3_3 bS3_3 0 8.1204k
RF3_3 a3_3 s3_3 100k
CFRF3_3 a3_3 s3_3 2p
R3_3_0 a2_0 s3_3 158k
R3_3_1 a2_1 s3_3 158k
R3_3_2 na2_2 s3_3 130k
R3_3_3 na2_3 s3_3 110k
R3_3_4 na2_4 s3_3 523k
R3_3_5 na2_5 s3_3 324k
R3_3_6 a2_6 s3_3 158k
R3_3_8 na2_8 s3_3 453k
R3_3_9 a2_9 s3_3 732k
R3_3_10 a2_10 s3_3 261k
R3_3_11 na2_11 s3_3 243k
R3_3_12 a2_12 s3_3 464k
R3_3_13 a2_13 s3_3 165k
R3_3_14 a2_14 s3_3 715k
R3_3_15 a2_15 s3_3 1.87Meg
R3_3_16 a2_16 s3_3 174k
R3_3_17 a2_17 s3_3 97.6k
R3_3_18 na2_18 s3_3 174k
R3_3_19 a2_19 s3_3 243k
R3_3_21 na2_21 s3_3 422k
R3_3_23 na2_23 s3_3 301k
R3_3_24 na2_24 s3_3 634k
R3_3_25 na2_25 s3_3 2.61Meg
R3_3_26 na2_26 s3_3 698k
R3_3_27 na2_27 s3_3 649k
R3_3_28 a2_28 s3_3 130k
R3_3_30 a2_30 s3_3 196k
R3_3_31 na2_31 s3_3 698k
XI3_3 bI3_3 si3_3 vcc vee na3_3 LT1810
RBALI3_3 bI3_3 0 50k
RIA3_3 a3_3 si3_3 100k
RIF3_3 na3_3 si3_3 100k
CFRIF3_3 na3_3 si3_3 2p
XS3_4 bS3_4 s3_4 vcc veer a3_4 LT1810
RBALS3_4 bS3_4 0 8.56442k
RF3_4 a3_4 s3_4 100k
CFRF3_4 a3_4 s3_4 2p
R3_4_0 a2_0 s3_4 576k
R3_4_1 na2_1 s3_4 1.33Meg
R3_4_2 a2_2 s3_4 309k
R3_4_3 na2_3 s3_4 412k
R3_4_4 a2_4 s3_4 274k
R3_4_5 na2_5 s3_4 210k
R3_4_6 a2_6 s3_4 681k
R3_4_8 a2_8 s3_4 681k
R3_4_9 a2_9 s3_4 150k
R3_4_10 na2_10 s3_4 232k
R3_4_11 na2_11 s3_4 332k
R3_4_12 na2_12 s3_4 113k
R3_4_13 a2_13 s3_4 383k
R3_4_14 a2_14 s3_4 215k
R3_4_15 a2_15 s3_4 402k
R3_4_16 na2_16 s3_4 243k
R3_4_17 na2_17 s3_4 187k
R3_4_18 a2_18 s3_4 453k
R3_4_19 na2_19 s3_4 221k
R3_4_20 a2_20 s3_4 210k
R3_4_22 na2_22 s3_4 1.13Meg
R3_4_23 na2_23 s3_4 953k
R3_4_24 na2_24 s3_4 215k
R3_4_25 a2_25 s3_4 133k
R3_4_26 a2_26 s3_4 1.58Meg
R3_4_27 a2_27 s3_4 110k
R3_4_28 na2_28 s3_4 280k
R3_4_29 na2_29 s3_4 1.54Meg
R3_4_30 a2_30 s3_4 536k
R3_4_31 na2_31 s3_4 422k
RB3_4 bn s3_4 698k
XI3_4 bI3_4 si3_4 vcc vee na3_4 LT1810
RBALI3_4 bI3_4 0 50k
RIA3_4 a3_4 si3_4 100k
RIF3_4 na3_4 si3_4 100k
CFRIF3_4 na3_4 si3_4 2p
XS3_5 bS3_5 s3_5 vcc veer a3_5 LT1810
RBALS3_5 bS3_5 0 8.68281k
RF3_5 a3_5 s3_5 100k
CFRF3_5 a3_5 s3_5 2p
R3_5_0 na2_0 s3_5 499k
R3_5_1 na2_1 s3_5 232k
R3_5_2 a2_2 s3_5 243k
R3_5_3 na2_3 s3_5 453k
R3_5_4 a2_4 s3_5 523k
R3_5_5 a2_5 s3_5 1.24Meg
R3_5_6 a2_6 s3_5 1.05Meg
R3_5_7 na2_7 s3_5 169k
R3_5_8 a2_8 s3_5 169k
R3_5_9 na2_9 s3_5 1.58Meg
R3_5_10 a2_10 s3_5 158k
R3_5_11 na2_11 s3_5 453k
R3_5_12 na2_12 s3_5 221k
R3_5_13 a2_13 s3_5 165k
R3_5_14 a2_14 s3_5 243k
R3_5_15 a2_15 s3_5 464k
R3_5_16 na2_16 s3_5 487k
R3_5_17 na2_17 s3_5 243k
R3_5_18 na2_18 s3_5 464k
R3_5_19 na2_19 s3_5 261k
R3_5_20 na2_20 s3_5 357k
R3_5_21 na2_21 s3_5 324k
R3_5_22 a2_22 s3_5 1.24Meg
R3_5_23 a2_23 s3_5 432k
R3_5_25 na2_25 s3_5 294k
R3_5_26 a2_26 s3_5 221k
R3_5_27 a2_27 s3_5 374k
R3_5_28 na2_28 s3_5 261k
R3_5_29 na2_29 s3_5 806k
R3_5_30 a2_30 s3_5 178k
R3_5_31 na2_31 s3_5 174k
RB3_5 bn s3_5 357k
XI3_5 bI3_5 si3_5 vcc vee na3_5 LT1810
RBALI3_5 bI3_5 0 50k
RIA3_5 a3_5 si3_5 100k
RIF3_5 na3_5 si3_5 100k
CFRIF3_5 na3_5 si3_5 2p
XS3_6 bS3_6 s3_6 vcc veer a3_6 LT1810
RBALS3_6 bS3_6 0 6.84027k
RF3_6 a3_6 s3_6 100k
CFRF3_6 a3_6 s3_6 2p
R3_6_0 a2_0 s3_6 549k
R3_6_1 a2_1 s3_6 210k
R3_6_2 na2_2 s3_6 105k
R3_6_3 a2_3 s3_6 187k
R3_6_4 a2_4 s3_6 1.74Meg
R3_6_5 na2_5 s3_6 340k
R3_6_6 a2_6 s3_6 316k
R3_6_7 na2_7 s3_6 118k
R3_6_8 na2_8 s3_6 681k
R3_6_9 na2_9 s3_6 1.05Meg
R3_6_10 a2_10 s3_6 383k
R3_6_11 a2_11 s3_6 162k
R3_6_12 a2_12 s3_6 196k
R3_6_13 a2_13 s3_6 107k
R3_6_14 a2_14 s3_6 124k
R3_6_15 na2_15 s3_6 487k
R3_6_16 a2_16 s3_6 549k
R3_6_17 na2_17 s3_6 215k
R3_6_18 na2_18 s3_6 1.82Meg
R3_6_19 na2_19 s3_6 324k
R3_6_20 na2_20 s3_6 84.5k
R3_6_21 na2_21 s3_6 392k
R3_6_22 a2_22 s3_6 196k
R3_6_23 a2_23 s3_6 267k
R3_6_24 na2_24 s3_6 665k
R3_6_25 a2_25 s3_6 200k
R3_6_26 na2_26 s3_6 261k
R3_6_27 a2_27 s3_6 102k
R3_6_28 na2_28 s3_6 237k
R3_6_29 na2_29 s3_6 357k
R3_6_30 na2_30 s3_6 1.96Meg
R3_6_31 na2_31 s3_6 549k
RB3_6 bn s3_6 1.02Meg
XI3_6 bI3_6 si3_6 vcc vee na3_6 LT1810
RBALI3_6 bI3_6 0 50k
RIA3_6 a3_6 si3_6 100k
RIF3_6 na3_6 si3_6 100k
CFRIF3_6 na3_6 si3_6 2p
XS3_7 bS3_7 s3_7 vcc veer a3_7 LT1810
RBALS3_7 bS3_7 0 7.75681k
RF3_7 a3_7 s3_7 100k
CFRF3_7 a3_7 s3_7 2p
R3_7_0 a2_0 s3_7 294k
R3_7_1 na2_1 s3_7 1.43Meg
R3_7_2 a2_2 s3_7 137k
R3_7_3 na2_3 s3_7 2.05Meg
R3_7_4 a2_4 s3_7 187k
R3_7_5 a2_5 s3_7 383k
R3_7_6 na2_6 s3_7 205k
R3_7_7 a2_7 s3_7 309k
R3_7_8 na2_8 s3_7 357k
R3_7_9 a2_9 s3_7 169k
R3_7_10 na2_10 s3_7 825k
R3_7_11 a2_11 s3_7 178k
R3_7_12 na2_12 s3_7 274k
R3_7_13 a2_13 s3_7 909k
R3_7_14 na2_14 s3_7 866k
R3_7_15 a2_15 s3_7 158k
R3_7_17 na2_17 s3_7 340k
R3_7_18 na2_18 s3_7 127k
R3_7_19 na2_19 s3_7 280k
R3_7_20 na2_20 s3_7 1.02Meg
R3_7_22 a2_22 s3_7 261k
R3_7_24 a2_24 s3_7 162k
R3_7_25 na2_25 s3_7 1.05Meg
R3_7_26 na2_26 s3_7 215k
R3_7_27 na2_27 s3_7 549k
R3_7_28 na2_28 s3_7 121k
R3_7_29 na2_29 s3_7 105k
R3_7_30 na2_30 s3_7 301k
R3_7_31 na2_31 s3_7 130k
RB3_7 bn s3_7 634k
XI3_7 bI3_7 si3_7 vcc vee na3_7 LT1810
RBALI3_7 bI3_7 0 50k
RIA3_7 a3_7 si3_7 100k
RIF3_7 na3_7 si3_7 100k
CFRIF3_7 na3_7 si3_7 2p
XS3_8 bS3_8 s3_8 vcc veer a3_8 LT1810
RBALS3_8 bS3_8 0 13.9896k
RF3_8 a3_8 s3_8 100k
CFRF3_8 a3_8 s3_8 2p
R3_8_0 na2_0 s3_8 1Meg
R3_8_1 a2_1 s3_8 1.69Meg
R3_8_2 na2_2 s3_8 1.13Meg
R3_8_4 a2_4 s3_8 374k
R3_8_5 a2_5 s3_8 309k
R3_8_7 a2_7 s3_8 681k
R3_8_8 a2_8 s3_8 267k
R3_8_9 a2_9 s3_8 402k
R3_8_10 a2_10 s3_8 453k
R3_8_11 a2_11 s3_8 402k
R3_8_12 a2_12 s3_8 243k
R3_8_13 a2_13 s3_8 1.4Meg
R3_8_15 a2_15 s3_8 196k
R3_8_16 a2_16 s3_8 332k
R3_8_17 a2_17 s3_8 2.49Meg
R3_8_18 na2_18 s3_8 374k
R3_8_20 na2_20 s3_8 2.26Meg
R3_8_21 a2_21 s3_8 316k
R3_8_22 a2_22 s3_8 1.47Meg
R3_8_23 a2_23 s3_8 2.1Meg
R3_8_24 na2_24 s3_8 332k
R3_8_25 a2_25 s3_8 210k
R3_8_26 a2_26 s3_8 383k
R3_8_27 a2_27 s3_8 562k
R3_8_29 na2_29 s3_8 453k
R3_8_30 na2_30 s3_8 348k
R3_8_31 a2_31 s3_8 576k
RB3_8 bp s3_8 1.07Meg
XI3_8 bI3_8 si3_8 vcc vee na3_8 LT1810
RBALI3_8 bI3_8 0 50k
RIA3_8 a3_8 si3_8 100k
RIF3_8 na3_8 si3_8 100k
CFRIF3_8 na3_8 si3_8 2p
XS3_9 bS3_9 s3_9 vcc veer a3_9 LT1810
RBALS3_9 bS3_9 0 8.84833k
RF3_9 a3_9 s3_9 100k
CFRF3_9 a3_9 s3_9 2p
R3_9_0 a2_0 s3_9 191k
R3_9_1 na2_1 s3_9 562k
R3_9_2 a2_2 s3_9 105k
R3_9_3 a2_3 s3_9 309k
R3_9_4 na2_4 s3_9 562k
R3_9_5 a2_5 s3_9 200k
R3_9_6 na2_6 s3_9 2.55Meg
R3_9_7 na2_7 s3_9 536k
R3_9_8 a2_8 s3_9 105k
R3_9_9 na2_9 s3_9 205k
R3_9_10 a2_10 s3_9 357k
R3_9_12 na2_12 s3_9 158k
R3_9_13 na2_13 s3_9 165k
R3_9_14 a2_14 s3_9 261k
R3_9_15 a2_15 s3_9 243k
R3_9_16 na2_16 s3_9 787k
R3_9_17 na2_17 s3_9 511k
R3_9_18 na2_18 s3_9 1Meg
R3_9_19 na2_19 s3_9 210k
R3_9_20 na2_20 s3_9 113k
R3_9_21 a2_21 s3_9 649k
R3_9_22 na2_22 s3_9 1.27Meg
R3_9_24 na2_24 s3_9 806k
R3_9_25 a2_25 s3_9 475k
R3_9_28 na2_28 s3_9 165k
R3_9_29 a2_29 s3_9 887k
R3_9_30 a2_30 s3_9 340k
R3_9_31 na2_31 s3_9 732k
RB3_9 bn s3_9 604k
XI3_9 bI3_9 si3_9 vcc vee na3_9 LT1810
RBALI3_9 bI3_9 0 50k
RIA3_9 a3_9 si3_9 100k
RIF3_9 na3_9 si3_9 100k
CFRIF3_9 na3_9 si3_9 2p
XS3_10 bS3_10 s3_10 vcc veer a3_10 LT1810
RBALS3_10 bS3_10 0 8.06865k
RF3_10 a3_10 s3_10 100k
CFRF3_10 a3_10 s3_10 2p
R3_10_0 na2_0 s3_10 232k
R3_10_2 na2_2 s3_10 412k
R3_10_3 na2_3 s3_10 191k
R3_10_4 na2_4 s3_10 205k
R3_10_5 na2_5 s3_10 113k
R3_10_6 a2_6 s3_10 787k
R3_10_7 a2_7 s3_10 442k
R3_10_8 na2_8 s3_10 649k
R3_10_9 na2_9 s3_10 154k
R3_10_10 na2_10 s3_10 237k
R3_10_11 na2_11 s3_10 1.24Meg
R3_10_12 na2_12 s3_10 511k
R3_10_13 na2_13 s3_10 357k
R3_10_16 a2_16 s3_10 165k
R3_10_17 a2_17 s3_10 255k
R3_10_18 a2_18 s3_10 237k
R3_10_19 na2_19 s3_10 140k
R3_10_20 na2_20 s3_10 162k
R3_10_21 a2_21 s3_10 243k
R3_10_22 a2_22 s3_10 402k
R3_10_23 a2_23 s3_10 274k
R3_10_24 na2_24 s3_10 249k
R3_10_25 a2_25 s3_10 255k
R3_10_26 a2_26 s3_10 499k
R3_10_27 a2_27 s3_10 121k
R3_10_28 na2_28 s3_10 649k
R3_10_29 na2_29 s3_10 200k
R3_10_30 a2_30 s3_10 442k
R3_10_31 na2_31 s3_10 475k
XI3_10 bI3_10 si3_10 vcc vee na3_10 LT1810
RBALI3_10 bI3_10 0 50k
RIA3_10 a3_10 si3_10 100k
RIF3_10 na3_10 si3_10 100k
CFRIF3_10 na3_10 si3_10 2p
XS3_11 bS3_11 s3_11 vcc veer a3_11 LT1810
RBALS3_11 bS3_11 0 8.07475k
RF3_11 a3_11 s3_11 100k
CFRF3_11 a3_11 s3_11 2p
R3_11_0 na2_0 s3_11 549k
R3_11_1 a2_1 s3_11 511k
R3_11_2 a2_2 s3_11 121k
R3_11_3 a2_3 s3_11 133k
R3_11_4 a2_4 s3_11 715k
R3_11_5 a2_5 s3_11 383k
R3_11_6 na2_6 s3_11 383k
R3_11_7 a2_7 s3_11 174k
R3_11_8 na2_8 s3_11 487k
R3_11_9 na2_9 s3_11 187k
R3_11_10 a2_10 s3_11 137k
R3_11_13 na2_13 s3_11 200k
R3_11_14 na2_14 s3_11 127k
R3_11_15 a2_15 s3_11 294k
R3_11_16 a2_16 s3_11 562k
R3_11_17 na2_17 s3_11 267k
R3_11_18 na2_18 s3_11 464k
R3_11_19 na2_19 s3_11 422k
R3_11_20 na2_20 s3_11 261k
R3_11_21 na2_21 s3_11 178k
R3_11_23 na2_23 s3_11 732k
R3_11_24 a2_24 s3_11 383k
R3_11_25 na2_25 s3_11 619k
R3_11_26 a2_26 s3_11 182k
R3_11_27 na2_27 s3_11 576k
R3_11_28 na2_28 s3_11 294k
R3_11_29 a2_29 s3_11 649k
R3_11_30 na2_30 s3_11 196k
R3_11_31 a2_31 s3_11 200k
RB3_11 bn s3_11 280k
XI3_11 bI3_11 si3_11 vcc vee na3_11 LT1810
RBALI3_11 bI3_11 0 50k
RIA3_11 a3_11 si3_11 100k
RIF3_11 na3_11 si3_11 100k
CFRIF3_11 na3_11 si3_11 2p
XS3_12 bS3_12 s3_12 vcc veer a3_12 LT1810
RBALS3_12 bS3_12 0 7.51595k
RF3_12 a3_12 s3_12 100k
CFRF3_12 a3_12 s3_12 2p
R3_12_0 na2_0 s3_12 237k
R3_12_1 na2_1 s3_12 866k
R3_12_2 a2_2 s3_12 210k
R3_12_3 a2_3 s3_12 243k
R3_12_4 na2_4 s3_12 511k
R3_12_5 na2_5 s3_12 147k
R3_12_6 na2_6 s3_12 154k
R3_12_7 na2_7 s3_12 1.24Meg
R3_12_8 na2_8 s3_12 102k
R3_12_9 na2_9 s3_12 887k
R3_12_10 na2_10 s3_12 280k
R3_12_11 a2_11 s3_12 237k
R3_12_12 a2_12 s3_12 464k
R3_12_13 a2_13 s3_12 78.7k
R3_12_14 a2_14 s3_12 845k
R3_12_15 na2_15 s3_12 200k
R3_12_16 a2_16 s3_12 487k
R3_12_17 a2_17 s3_12 221k
R3_12_18 na2_18 s3_12 2.74Meg
R3_12_19 a2_19 s3_12 402k
R3_12_20 na2_20 s3_12 274k
R3_12_21 a2_21 s3_12 178k
R3_12_22 na2_22 s3_12 549k
R3_12_23 a2_23 s3_12 698k
R3_12_24 na2_24 s3_12 255k
R3_12_25 a2_25 s3_12 1.13Meg
R3_12_26 a2_26 s3_12 365k
R3_12_27 a2_27 s3_12 316k
R3_12_28 na2_28 s3_12 191k
R3_12_29 na2_29 s3_12 182k
R3_12_30 na2_30 s3_12 154k
R3_12_31 na2_31 s3_12 374k
RB3_12 bn s3_12 2.43Meg
XI3_12 bI3_12 si3_12 vcc vee na3_12 LT1810
RBALI3_12 bI3_12 0 50k
RIA3_12 a3_12 si3_12 100k
RIF3_12 na3_12 si3_12 100k
CFRIF3_12 na3_12 si3_12 2p
XS3_13 bS3_13 s3_13 vcc veer a3_13 LT1810
RBALS3_13 bS3_13 0 9.17973k
RF3_13 a3_13 s3_13 100k
CFRF3_13 a3_13 s3_13 2p
R3_13_0 a2_0 s3_13 200k
R3_13_1 na2_1 s3_13 750k
R3_13_2 na2_2 s3_13 324k
R3_13_3 a2_3 s3_13 215k
R3_13_4 a2_4 s3_13 1.69Meg
R3_13_5 na2_5 s3_13 221k
R3_13_6 a2_6 s3_13 274k
R3_13_7 na2_7 s3_13 147k
R3_13_8 a2_8 s3_13 357k
R3_13_9 a2_9 s3_13 332k
R3_13_10 na2_10 s3_13 2.05Meg
R3_13_11 a2_11 s3_13 1.78Meg
R3_13_12 a2_12 s3_13 107k
R3_13_13 a2_13 s3_13 154k
R3_13_14 a2_14 s3_13 309k
R3_13_15 na2_15 s3_13 267k
R3_13_16 na2_16 s3_13 200k
R3_13_18 a2_18 s3_13 422k
R3_13_19 a2_19 s3_13 464k
R3_13_20 na2_20 s3_13 511k
R3_13_21 na2_21 s3_13 536k
R3_13_22 na2_22 s3_13 536k
R3_13_24 na2_24 s3_13 196k
R3_13_25 na2_25 s3_13 453k
R3_13_26 na2_26 s3_13 174k
R3_13_27 a2_27 s3_13 549k
R3_13_28 na2_28 s3_13 402k
R3_13_29 a2_29 s3_13 255k
R3_13_30 na2_30 s3_13 511k
RB3_13 bn s3_13 866k
XI3_13 bI3_13 si3_13 vcc vee na3_13 LT1810
RBALI3_13 bI3_13 0 50k
RIA3_13 a3_13 si3_13 100k
RIF3_13 na3_13 si3_13 100k
CFRIF3_13 na3_13 si3_13 2p
XS3_14 bS3_14 s3_14 vcc veer a3_14 LT1810
RBALS3_14 bS3_14 0 8.88981k
RF3_14 a3_14 s3_14 100k
CFRF3_14 a3_14 s3_14 2p
R3_14_0 a2_0 s3_14 169k
R3_14_1 na2_1 s3_14 294k
R3_14_2 na2_2 s3_14 232k
R3_14_3 a2_3 s3_14 604k
R3_14_4 a2_4 s3_14 143k
R3_14_6 na2_6 s3_14 324k
R3_14_7 a2_7 s3_14 806k
R3_14_8 a2_8 s3_14 487k
R3_14_9 a2_9 s3_14 287k
R3_14_10 na2_10 s3_14 1.87Meg
R3_14_11 na2_11 s3_14 549k
R3_14_12 na2_12 s3_14 124k
R3_14_13 a2_13 s3_14 1.3Meg
R3_14_14 na2_14 s3_14 154k
R3_14_15 na2_15 s3_14 715k
R3_14_16 na2_16 s3_14 165k
R3_14_17 a2_17 s3_14 1.05Meg
R3_14_18 na2_18 s3_14 294k
R3_14_19 na2_19 s3_14 140k
R3_14_20 a2_20 s3_14 147k
R3_14_21 a2_21 s3_14 287k
R3_14_22 a2_22 s3_14 287k
R3_14_23 a2_23 s3_14 1.43Meg
R3_14_25 a2_25 s3_14 374k
R3_14_27 a2_27 s3_14 634k
R3_14_28 a2_28 s3_14 649k
R3_14_29 a2_29 s3_14 226k
R3_14_30 a2_30 s3_14 294k
R3_14_31 a2_31 s3_14 178k
XI3_14 bI3_14 si3_14 vcc vee na3_14 LT1810
RBALI3_14 bI3_14 0 50k
RIA3_14 a3_14 si3_14 100k
RIF3_14 na3_14 si3_14 100k
CFRIF3_14 na3_14 si3_14 2p
XS3_15 bS3_15 s3_15 vcc veer a3_15 LT1810
RBALS3_15 bS3_15 0 7.44121k
RF3_15 a3_15 s3_15 100k
CFRF3_15 a3_15 s3_15 2p
R3_15_0 na2_0 s3_15 2.55Meg
R3_15_1 na2_1 s3_15 115k
R3_15_2 a2_2 s3_15 1.58Meg
R3_15_3 a2_3 s3_15 316k
R3_15_4 na2_4 s3_15 1.54Meg
R3_15_5 na2_5 s3_15 866k
R3_15_6 na2_6 s3_15 118k
R3_15_7 a2_7 s3_15 121k
R3_15_8 na2_8 s3_15 187k
R3_15_10 na2_10 s3_15 294k
R3_15_11 a2_11 s3_15 365k
R3_15_12 a2_12 s3_15 140k
R3_15_13 na2_13 s3_15 200k
R3_15_14 na2_14 s3_15 825k
R3_15_15 a2_15 s3_15 287k
R3_15_16 na2_16 s3_15 1.69Meg
R3_15_17 a2_17 s3_15 143k
R3_15_18 na2_18 s3_15 113k
R3_15_19 a2_19 s3_15 178k
R3_15_20 a2_20 s3_15 287k
R3_15_21 na2_21 s3_15 301k
R3_15_22 na2_22 s3_15 316k
R3_15_23 na2_23 s3_15 133k
R3_15_24 a2_24 s3_15 576k
R3_15_25 na2_25 s3_15 243k
R3_15_26 na2_26 s3_15 178k
R3_15_27 na2_27 s3_15 909k
R3_15_28 na2_28 s3_15 332k
R3_15_29 a2_29 s3_15 340k
R3_15_30 na2_30 s3_15 365k
R3_15_31 a2_31 s3_15 976k
RB3_15 bn s3_15 357k
XI3_15 bI3_15 si3_15 vcc vee na3_15 LT1810
RBALI3_15 bI3_15 0 50k
RIA3_15 a3_15 si3_15 100k
RIF3_15 na3_15 si3_15 100k
CFRIF3_15 na3_15 si3_15 2p
XS3_16 bS3_16 s3_16 vcc veer a3_16 LT1810
RBALS3_16 bS3_16 0 8.08962k
RF3_16 a3_16 s3_16 100k
CFRF3_16 a3_16 s3_16 2p
R3_16_0 a2_0 s3_16 590k
R3_16_1 na2_1 s3_16 1.33Meg
R3_16_2 na2_2 s3_16 169k
R3_16_3 na2_3 s3_16 402k
R3_16_4 a2_4 s3_16 274k
R3_16_5 na2_5 s3_16 210k
R3_16_6 na2_6 s3_16 200k
R3_16_7 a2_7 s3_16 768k
R3_16_8 na2_8 s3_16 124k
R3_16_9 a2_9 s3_16 732k
R3_16_10 a2_10 s3_16 150k
R3_16_11 na2_11 s3_16 255k
R3_16_12 na2_12 s3_16 143k
R3_16_13 na2_13 s3_16 442k
R3_16_14 na2_14 s3_16 1.1Meg
R3_16_15 a2_15 s3_16 1.3Meg
R3_16_16 na2_16 s3_16 261k
R3_16_17 na2_17 s3_16 226k
R3_16_18 a2_18 s3_16 1.13Meg
R3_16_19 na2_19 s3_16 113k
R3_16_20 a2_20 s3_16 107k
R3_16_21 a2_21 s3_16 442k
R3_16_22 a2_22 s3_16 536k
R3_16_23 na2_23 s3_16 2.32Meg
R3_16_24 a2_24 s3_16 649k
R3_16_25 a2_25 s3_16 205k
R3_16_26 a2_26 s3_16 162k
R3_16_27 na2_27 s3_16 750k
R3_16_28 a2_28 s3_16 453k
R3_16_29 a2_29 s3_16 205k
R3_16_30 a2_30 s3_16 422k
RB3_16 bn s3_16 549k
XI3_16 bI3_16 si3_16 vcc vee na3_16 LT1810
RBALI3_16 bI3_16 0 50k
RIA3_16 a3_16 si3_16 100k
RIF3_16 na3_16 si3_16 100k
CFRIF3_16 na3_16 si3_16 2p
XS3_17 bS3_17 s3_17 vcc veer a3_17 LT1810
RBALS3_17 bS3_17 0 7.3591k
RF3_17 a3_17 s3_17 100k
CFRF3_17 a3_17 s3_17 2p
R3_17_0 a2_0 s3_17 475k
R3_17_1 a2_1 s3_17 402k
R3_17_2 a2_2 s3_17 340k
R3_17_3 a2_3 s3_17 174k
R3_17_4 na2_4 s3_17 324k
R3_17_5 na2_5 s3_17 63.4k
R3_17_6 a2_6 s3_17 249k
R3_17_7 na2_7 s3_17 619k
R3_17_8 na2_8 s3_17 165k
R3_17_9 na2_9 s3_17 374k
R3_17_10 na2_10 s3_17 1.21Meg
R3_17_11 a2_11 s3_17 174k
R3_17_12 a2_12 s3_17 432k
R3_17_13 na2_13 s3_17 210k
R3_17_14 na2_14 s3_17 226k
R3_17_15 a2_15 s3_17 324k
R3_17_17 a2_17 s3_17 348k
R3_17_18 na2_18 s3_17 931k
R3_17_19 a2_19 s3_17 619k
R3_17_20 na2_20 s3_17 102k
R3_17_21 a2_21 s3_17 162k
R3_17_22 na2_22 s3_17 261k
R3_17_23 a2_23 s3_17 536k
R3_17_24 a2_24 s3_17 150k
R3_17_25 a2_25 s3_17 365k
R3_17_26 na2_26 s3_17 1.05Meg
R3_17_27 a2_27 s3_17 475k
R3_17_28 na2_28 s3_17 316k
R3_17_29 na2_29 s3_17 143k
R3_17_30 na2_30 s3_17 187k
R3_17_31 na2_31 s3_17 332k
XI3_17 bI3_17 si3_17 vcc vee na3_17 LT1810
RBALI3_17 bI3_17 0 50k
RIA3_17 a3_17 si3_17 100k
RIF3_17 na3_17 si3_17 100k
CFRIF3_17 na3_17 si3_17 2p
XS3_18 bS3_18 s3_18 vcc veer a3_18 LT1810
RBALS3_18 bS3_18 0 8.81122k
RF3_18 a3_18 s3_18 100k
CFRF3_18 a3_18 s3_18 2p
R3_18_0 a2_0 s3_18 237k
R3_18_1 na2_1 s3_18 196k
R3_18_2 a2_2 s3_18 604k
R3_18_3 na2_3 s3_18 301k
R3_18_4 na2_4 s3_18 432k
R3_18_5 a2_5 s3_18 1.3Meg
R3_18_6 na2_6 s3_18 255k
R3_18_7 na2_7 s3_18 442k
R3_18_8 a2_8 s3_18 150k
R3_18_9 a2_9 s3_18 169k
R3_18_10 a2_10 s3_18 178k
R3_18_11 na2_11 s3_18 590k
R3_18_12 na2_12 s3_18 536k
R3_18_13 na2_13 s3_18 1.07Meg
R3_18_14 na2_14 s3_18 196k
R3_18_15 na2_15 s3_18 215k
R3_18_16 na2_16 s3_18 187k
R3_18_17 na2_17 s3_18 523k
R3_18_18 na2_18 s3_18 453k
R3_18_19 a2_19 s3_18 237k
R3_18_20 a2_20 s3_18 147k
R3_18_22 a2_22 s3_18 2Meg
R3_18_23 na2_23 s3_18 1.91Meg
R3_18_24 a2_24 s3_18 332k
R3_18_25 a2_25 s3_18 255k
R3_18_26 na2_26 s3_18 523k
R3_18_27 a2_27 s3_18 1.3Meg
R3_18_28 na2_28 s3_18 845k
R3_18_29 a2_29 s3_18 100k
R3_18_30 a2_30 s3_18 1.02Meg
R3_18_31 a2_31 s3_18 402k
RB3_18 bn s3_18 590k
XI3_18 bI3_18 si3_18 vcc vee na3_18 LT1810
RBALI3_18 bI3_18 0 50k
RIA3_18 a3_18 si3_18 100k
RIF3_18 na3_18 si3_18 100k
CFRIF3_18 na3_18 si3_18 2p
XS3_19 bS3_19 s3_19 vcc veer a3_19 LT1810
RBALS3_19 bS3_19 0 6.83201k
RF3_19 a3_19 s3_19 100k
CFRF3_19 a3_19 s3_19 2p
R3_19_0 a2_0 s3_19 249k
R3_19_1 a2_1 s3_19 294k
R3_19_2 a2_2 s3_19 750k
R3_19_3 na2_3 s3_19 121k
R3_19_5 na2_5 s3_19 100k
R3_19_6 a2_6 s3_19 365k
R3_19_7 na2_7 s3_19 232k
R3_19_8 na2_8 s3_19 76.8k
R3_19_9 na2_9 s3_19 301k
R3_19_10 a2_10 s3_19 130k
R3_19_11 na2_11 s3_19 221k
R3_19_12 na2_12 s3_19 750k
R3_19_13 na2_13 s3_19 562k
R3_19_14 na2_14 s3_19 1.65Meg
R3_19_15 na2_15 s3_19 732k
R3_19_16 a2_16 s3_19 226k
R3_19_17 na2_17 s3_19 590k
R3_19_18 a2_18 s3_19 210k
R3_19_19 na2_19 s3_19 511k
R3_19_20 na2_20 s3_19 357k
R3_19_22 na2_22 s3_19 243k
R3_19_23 na2_23 s3_19 205k
R3_19_24 na2_24 s3_19 158k
R3_19_25 a2_25 s3_19 715k
R3_19_26 a2_26 s3_19 158k
R3_19_27 na2_27 s3_19 332k
R3_19_28 a2_28 s3_19 226k
R3_19_29 a2_29 s3_19 84.5k
R3_19_30 a2_30 s3_19 118k
R3_19_31 na2_31 s3_19 576k
RB3_19 bp s3_19 2.05Meg
XI3_19 bI3_19 si3_19 vcc vee na3_19 LT1810
RBALI3_19 bI3_19 0 50k
RIA3_19 a3_19 si3_19 100k
RIF3_19 na3_19 si3_19 100k
CFRIF3_19 na3_19 si3_19 2p
XS3_20 bS3_20 s3_20 vcc veer a3_20 LT1810
RBALS3_20 bS3_20 0 8.80636k
RF3_20 a3_20 s3_20 100k
CFRF3_20 a3_20 s3_20 2p
R3_20_0 a2_0 s3_20 1.74Meg
R3_20_1 na2_1 s3_20 237k
R3_20_2 na2_2 s3_20 698k
R3_20_3 a2_3 s3_20 130k
R3_20_4 na2_4 s3_20 169k
R3_20_5 na2_5 s3_20 412k
R3_20_6 na2_6 s3_20 768k
R3_20_7 na2_7 s3_20 383k
R3_20_8 a2_8 s3_20 205k
R3_20_9 na2_9 s3_20 301k
R3_20_11 a2_11 s3_20 154k
R3_20_12 na2_12 s3_20 154k
R3_20_13 a2_13 s3_20 210k
R3_20_14 a2_14 s3_20 1.54Meg
R3_20_15 na2_15 s3_20 825k
R3_20_16 a2_16 s3_20 374k
R3_20_17 na2_17 s3_20 422k
R3_20_18 na2_18 s3_20 274k
R3_20_19 na2_19 s3_20 143k
R3_20_20 na2_20 s3_20 274k
R3_20_21 na2_21 s3_20 261k
R3_20_22 a2_22 s3_20 133k
R3_20_24 a2_24 s3_20 1.37Meg
R3_20_25 a2_25 s3_20 174k
R3_20_26 na2_26 s3_20 1.5Meg
R3_20_27 a2_27 s3_20 274k
R3_20_28 a2_28 s3_20 523k
R3_20_29 a2_29 s3_20 309k
R3_20_30 a2_30 s3_20 2.67Meg
R3_20_31 a2_31 s3_20 1.43Meg
RB3_20 bn s3_20 536k
XI3_20 bI3_20 si3_20 vcc vee na3_20 LT1810
RBALI3_20 bI3_20 0 50k
RIA3_20 a3_20 si3_20 100k
RIF3_20 na3_20 si3_20 100k
CFRIF3_20 na3_20 si3_20 2p
XS3_21 bS3_21 s3_21 vcc veer a3_21 LT1810
RBALS3_21 bS3_21 0 9.12049k
RF3_21 a3_21 s3_21 100k
CFRF3_21 a3_21 s3_21 2p
R3_21_0 na2_0 s3_21 249k
R3_21_2 na2_2 s3_21 732k
R3_21_3 a2_3 s3_21 324k
R3_21_4 na2_4 s3_21 274k
R3_21_5 a2_5 s3_21 137k
R3_21_6 a2_6 s3_21 576k
R3_21_7 a2_7 s3_21 200k
R3_21_8 a2_8 s3_21 357k
R3_21_10 na2_10 s3_21 137k
R3_21_11 na2_11 s3_21 549k
R3_21_13 na2_13 s3_21 412k
R3_21_14 a2_14 s3_21 226k
R3_21_15 na2_15 s3_21 294k
R3_21_16 na2_16 s3_21 280k
R3_21_17 na2_17 s3_21 787k
R3_21_18 a2_18 s3_21 221k
R3_21_19 a2_19 s3_21 576k
R3_21_20 a2_20 s3_21 243k
R3_21_21 na2_21 s3_21 174k
R3_21_22 na2_22 s3_21 205k
R3_21_23 a2_23 s3_21 232k
R3_21_24 a2_24 s3_21 1.07Meg
R3_21_25 a2_25 s3_21 475k
R3_21_26 na2_26 s3_21 348k
R3_21_27 a2_27 s3_21 1.13Meg
R3_21_29 na2_29 s3_21 261k
R3_21_30 na2_30 s3_21 133k
RB3_21 bn s3_21 332k
XI3_21 bI3_21 si3_21 vcc vee na3_21 LT1810
RBALI3_21 bI3_21 0 50k
RIA3_21 a3_21 si3_21 100k
RIF3_21 na3_21 si3_21 100k
CFRIF3_21 na3_21 si3_21 2p
XS3_22 bS3_22 s3_22 vcc veer a3_22 LT1810
RBALS3_22 bS3_22 0 8.54283k
RF3_22 a3_22 s3_22 100k
CFRF3_22 a3_22 s3_22 2p
R3_22_0 na2_0 s3_22 392k
R3_22_1 na2_1 s3_22 825k
R3_22_2 a2_2 s3_22 604k
R3_22_3 a2_3 s3_22 84.5k
R3_22_4 a2_4 s3_22 1.37Meg
R3_22_5 a2_5 s3_22 140k
R3_22_6 a2_6 s3_22 442k
R3_22_7 a2_7 s3_22 162k
R3_22_8 a2_8 s3_22 182k
R3_22_9 na2_9 s3_22 162k
R3_22_12 na2_12 s3_22 267k
R3_22_13 a2_13 s3_22 165k
R3_22_14 na2_14 s3_22 487k
R3_22_15 a2_15 s3_22 226k
R3_22_16 na2_16 s3_22 324k
R3_22_18 a2_18 s3_22 825k
R3_22_19 na2_19 s3_22 140k
R3_22_20 na2_20 s3_22 150k
R3_22_21 na2_21 s3_22 162k
R3_22_23 na2_23 s3_22 698k
R3_22_24 na2_24 s3_22 191k
R3_22_26 a2_26 s3_22 562k
R3_22_27 a2_27 s3_22 619k
R3_22_28 a2_28 s3_22 422k
R3_22_29 na2_29 s3_22 357k
R3_22_30 a2_30 s3_22 324k
R3_22_31 na2_31 s3_22 732k
RB3_22 bn s3_22 634k
XI3_22 bI3_22 si3_22 vcc vee na3_22 LT1810
RBALI3_22 bI3_22 0 50k
RIA3_22 a3_22 si3_22 100k
RIF3_22 na3_22 si3_22 100k
CFRIF3_22 na3_22 si3_22 2p
XS3_23 bS3_23 s3_23 vcc veer a3_23 LT1810
RBALS3_23 bS3_23 0 8.22206k
RF3_23 a3_23 s3_23 100k
CFRF3_23 a3_23 s3_23 2p
R3_23_0 a2_0 s3_23 210k
R3_23_2 na2_2 s3_23 95.3k
R3_23_3 a2_3 s3_23 1.07Meg
R3_23_4 a2_4 s3_23 309k
R3_23_5 a2_5 s3_23 215k
R3_23_6 na2_6 s3_23 316k
R3_23_7 na2_7 s3_23 953k
R3_23_8 a2_8 s3_23 133k
R3_23_9 a2_9 s3_23 1.24Meg
R3_23_10 a2_10 s3_23 2.55Meg
R3_23_11 na2_11 s3_23 274k
R3_23_12 na2_12 s3_23 1.37Meg
R3_23_13 na2_13 s3_23 147k
R3_23_14 na2_14 s3_23 324k
R3_23_15 a2_15 s3_23 178k
R3_23_16 a2_16 s3_23 536k
R3_23_17 a2_17 s3_23 205k
R3_23_18 na2_18 s3_23 374k
R3_23_19 na2_19 s3_23 340k
R3_23_22 a2_22 s3_23 1Meg
R3_23_23 na2_23 s3_23 2Meg
R3_23_24 na2_24 s3_23 309k
R3_23_25 na2_25 s3_23 383k
R3_23_26 na2_26 s3_23 97.6k
R3_23_27 na2_27 s3_23 1.21Meg
R3_23_28 a2_28 s3_23 137k
R3_23_29 na2_29 s3_23 255k
R3_23_30 a2_30 s3_23 127k
R3_23_31 na2_31 s3_23 226k
RB3_23 bn s3_23 2.32Meg
XI3_23 bI3_23 si3_23 vcc vee na3_23 LT1810
RBALI3_23 bI3_23 0 50k
RIA3_23 a3_23 si3_23 100k
RIF3_23 na3_23 si3_23 100k
CFRIF3_23 na3_23 si3_23 2p
* ---- stage 4: 24 -> 16 (hidden, single-supply ReLU)
XS4_0 bS4_0 s4_0 vcc veer a4_0 LT1810
RBALS4_0 bS4_0 0 8.89269k
RF4_0 a4_0 s4_0 100k
CFRF4_0 a4_0 s4_0 2p
R4_0_0 na3_0 s4_0 619k
R4_0_1 a3_1 s4_0 649k
R4_0_2 a3_2 s4_0 243k
R4_0_3 a3_3 s4_0 487k
R4_0_4 na3_4 s4_0 1.1Meg
R4_0_5 na3_5 s4_0 931k
R4_0_6 a3_6 s4_0 105k
R4_0_7 na3_7 s4_0 267k
R4_0_8 na3_8 s4_0 154k
R4_0_9 a3_9 s4_0 221k
R4_0_10 na3_10 s4_0 200k
R4_0_11 a3_11 s4_0 511k
R4_0_12 a3_12 s4_0 348k
R4_0_13 a3_13 s4_0 324k
R4_0_14 na3_14 s4_0 127k
R4_0_15 na3_15 s4_0 825k
R4_0_16 na3_16 s4_0 1.54Meg
R4_0_17 na3_17 s4_0 102k
R4_0_18 na3_18 s4_0 255k
R4_0_19 a3_19 s4_0 63.4k
R4_0_20 na3_20 s4_0 237k
R4_0_21 na3_21 s4_0 137k
R4_0_22 a3_22 s4_0 768k
R4_0_23 a3_23 s4_0 1.37Meg
RB4_0 bp s4_0 866k
XI4_0 bI4_0 si4_0 vcc vee na4_0 LT1810
RBALI4_0 bI4_0 0 50k
RIA4_0 a4_0 si4_0 100k
RIF4_0 na4_0 si4_0 100k
CFRIF4_0 na4_0 si4_0 2p
XS4_1 bS4_1 s4_1 vcc veer a4_1 LT1810
RBALS4_1 bS4_1 0 8.45039k
RF4_1 a4_1 s4_1 100k
CFRF4_1 a4_1 s4_1 2p
R4_1_0 na3_0 s4_1 205k
R4_1_1 a3_1 s4_1 187k
R4_1_2 a3_2 s4_1 1.69Meg
R4_1_3 a3_3 s4_1 121k
R4_1_4 na3_4 s4_1 392k
R4_1_5 a3_5 s4_1 124k
R4_1_6 a3_6 s4_1 59k
R4_1_7 a3_7 s4_1 1.21Meg
R4_1_8 a3_8 s4_1 1.5Meg
R4_1_9 a3_9 s4_1 453k
R4_1_10 na3_10 s4_1 249k
R4_1_11 na3_11 s4_1 78.7k
R4_1_12 na3_12 s4_1 113k
R4_1_14 na3_14 s4_1 825k
R4_1_15 na3_15 s4_1 261k
R4_1_16 a3_16 s4_1 665k
R4_1_17 a3_17 s4_1 226k
R4_1_18 a3_18 s4_1 255k
R4_1_19 na3_19 s4_1 2.15Meg
R4_1_20 na3_20 s4_1 1.18Meg
R4_1_21 na3_21 s4_1 301k
R4_1_22 na3_22 s4_1 267k
R4_1_23 a3_23 s4_1 127k
RB4_1 bn s4_1 787k
XI4_1 bI4_1 si4_1 vcc vee na4_1 LT1810
RBALI4_1 bI4_1 0 50k
RIA4_1 a4_1 si4_1 100k
RIF4_1 na4_1 si4_1 100k
CFRIF4_1 na4_1 si4_1 2p
XS4_2 bS4_2 s4_2 vcc veer a4_2 LT1810
RBALS4_2 bS4_2 0 9.92302k
RF4_2 a4_2 s4_2 100k
CFRF4_2 a4_2 s4_2 2p
R4_2_0 a3_0 s4_2 1.05Meg
R4_2_2 a3_2 s4_2 1.13Meg
R4_2_3 a3_3 s4_2 182k
R4_2_4 a3_4 s4_2 1.62Meg
R4_2_5 a3_5 s4_2 140k
R4_2_6 na3_6 s4_2 402k
R4_2_7 na3_7 s4_2 102k
R4_2_8 na3_8 s4_2 200k
R4_2_9 na3_9 s4_2 243k
R4_2_10 na3_10 s4_2 143k
R4_2_11 na3_11 s4_2 221k
R4_2_12 na3_12 s4_2 243k
R4_2_13 a3_13 s4_2 464k
R4_2_14 a3_14 s4_2 845k
R4_2_15 na3_15 s4_2 187k
R4_2_16 a3_16 s4_2 255k
R4_2_17 a3_17 s4_2 294k
R4_2_18 a3_18 s4_2 243k
R4_2_19 na3_19 s4_2 412k
R4_2_20 na3_20 s4_2 1.24Meg
R4_2_21 a3_21 s4_2 84.5k
R4_2_22 a3_22 s4_2 1.15Meg
R4_2_23 a3_23 s4_2 845k
RB4_2 bp s4_2 715k
XI4_2 bI4_2 si4_2 vcc vee na4_2 LT1810
RBALI4_2 bI4_2 0 50k
RIA4_2 a4_2 si4_2 100k
RIF4_2 na4_2 si4_2 100k
CFRIF4_2 na4_2 si4_2 2p
XS4_3 bS4_3 s4_3 vcc veer a4_3 LT1810
RBALS4_3 bS4_3 0 7.67427k
RF4_3 a4_3 s4_3 100k
CFRF4_3 a4_3 s4_3 2p
R4_3_0 na3_0 s4_3 243k
R4_3_1 na3_1 s4_3 113k
R4_3_2 na3_2 s4_3 324k
R4_3_3 a3_3 s4_3 95.3k
R4_3_4 na3_4 s4_3 210k
R4_3_5 na3_5 s4_3 133k
R4_3_6 a3_6 s4_3 1.24Meg
R4_3_7 na3_7 s4_3 665k
R4_3_8 a3_8 s4_3 232k
R4_3_9 na3_9 s4_3 294k
R4_3_10 na3_10 s4_3 261k
R4_3_11 na3_11 s4_3 115k
R4_3_12 a3_12 s4_3 88.7k
R4_3_13 a3_13 s4_3 200k
R4_3_14 na3_14 s4_3 2.55Meg
R4_3_15 na3_15 s4_3 392k
R4_3_16 na3_16 s4_3 118k
R4_3_17 na3_17 s4_3 383k
R4_3_18 na3_18 s4_3 158k
R4_3_19 a3_19 s4_3 182k
R4_3_20 na3_20 s4_3 549k
R4_3_21 na3_21 s4_3 287k
R4_3_22 na3_22 s4_3 118k
R4_3_23 na3_23 s4_3 1.15Meg
RB4_3 bn s4_3 464k
XI4_3 bI4_3 si4_3 vcc vee na4_3 LT1810
RBALI4_3 bI4_3 0 50k
RIA4_3 a4_3 si4_3 100k
RIF4_3 na4_3 si4_3 100k
CFRIF4_3 na4_3 si4_3 2p
XS4_4 bS4_4 s4_4 vcc veer a4_4 LT1810
RBALS4_4 bS4_4 0 12.3819k
RF4_4 a4_4 s4_4 100k
CFRF4_4 a4_4 s4_4 2p
R4_4_0 na3_0 s4_4 357k
R4_4_1 a3_1 s4_4 187k
R4_4_2 na3_2 s4_4 249k
R4_4_3 na3_3 s4_4 1.82Meg
R4_4_4 a3_4 s4_4 499k
R4_4_5 a3_5 s4_4 357k
R4_4_6 na3_6 s4_4 113k
R4_4_7 a3_7 s4_4 140k
R4_4_8 a3_8 s4_4 1.18Meg
R4_4_9 a3_9 s4_4 931k
R4_4_11 a3_11 s4_4 1.21Meg
R4_4_12 na3_12 s4_4 976k
R4_4_13 na3_13 s4_4 340k
R4_4_14 na3_14 s4_4 221k
R4_4_16 na3_16 s4_4 732k
R4_4_17 na3_17 s4_4 1.78Meg
R4_4_18 a3_18 s4_4 845k
R4_4_19 na3_19 s4_4 113k
R4_4_20 na3_20 s4_4 221k
R4_4_21 na3_21 s4_4 210k
R4_4_22 a3_22 s4_4 422k
R4_4_23 na3_23 s4_4 866k
RB4_4 bn s4_4 806k
XI4_4 bI4_4 si4_4 vcc vee na4_4 LT1810
RBALI4_4 bI4_4 0 50k
RIA4_4 a4_4 si4_4 100k
RIF4_4 na4_4 si4_4 100k
CFRIF4_4 na4_4 si4_4 2p
XS4_5 bS4_5 s4_5 vcc veer a4_5 LT1810
RBALS4_5 bS4_5 0 9.02429k
RF4_5 a4_5 s4_5 100k
CFRF4_5 a4_5 s4_5 2p
R4_5_0 na3_0 s4_5 976k
R4_5_1 na3_1 s4_5 165k
R4_5_2 a3_2 s4_5 191k
R4_5_3 na3_3 s4_5 115k
R4_5_4 na3_4 s4_5 412k
R4_5_5 na3_5 s4_5 105k
R4_5_6 na3_6 s4_5 787k
R4_5_7 na3_7 s4_5 178k
R4_5_8 a3_8 s4_5 357k
R4_5_9 na3_9 s4_5 931k
R4_5_10 a3_10 s4_5 499k
R4_5_11 na3_11 s4_5 158k
R4_5_12 a3_12 s4_5 110k
R4_5_13 a3_13 s4_5 191k
R4_5_14 na3_14 s4_5 374k
R4_5_15 na3_15 s4_5 374k
R4_5_16 na3_16 s4_5 1.18Meg
R4_5_17 a3_17 s4_5 127k
R4_5_19 na3_19 s4_5 130k
R4_5_20 a3_20 s4_5 274k
R4_5_21 a3_21 s4_5 464k
R4_5_22 na3_22 s4_5 243k
R4_5_23 na3_23 s4_5 365k
XI4_5 bI4_5 si4_5 vcc vee na4_5 LT1810
RBALI4_5 bI4_5 0 50k
RIA4_5 a4_5 si4_5 100k
RIF4_5 na4_5 si4_5 100k
CFRIF4_5 na4_5 si4_5 2p
XS4_6 bS4_6 s4_6 vcc veer a4_6 LT1810
RBALS4_6 bS4_6 0 9.82905k
RF4_6 a4_6 s4_6 100k
CFRF4_6 a4_6 s4_6 2p
R4_6_0 na3_0 s4_6 124k
R4_6_1 a3_1 s4_6 261k
R4_6_2 a3_2 s4_6 2.67Meg
R4_6_3 a3_3 s4_6 174k
R4_6_4 a3_4 s4_6 1.47Meg
R4_6_5 a3_5 s4_6 267k
R4_6_6 na3_6 s4_6 1.13Meg
R4_6_7 na3_7 s4_6 604k
R4_6_8 na3_8 s4_6 453k
R4_6_9 na3_9 s4_6 182k
R4_6_10 a3_10 s4_6 200k
R4_6_11 a3_11 s4_6 909k
R4_6_12 a3_12 s4_6 357k
R4_6_13 na3_13 s4_6 226k
R4_6_14 na3_14 s4_6 976k
R4_6_15 na3_15 s4_6 274k
R4_6_16 na3_16 s4_6 715k
R4_6_18 a3_18 s4_6 267k
R4_6_19 a3_19 s4_6 118k
R4_6_20 na3_20 s4_6 110k
R4_6_21 na3_21 s4_6 412k
R4_6_22 na3_22 s4_6 118k
R4_6_23 na3_23 s4_6 174k
RB4_6 bn s4_6 590k
XI4_6 bI4_6 si4_6 vcc vee na4_6 LT1810
RBALI4_6 bI4_6 0 50k
RIA4_6 a4_6 si4_6 100k
RIF4_6 na4_6 si4_6 100k
CFRIF4_6 na4_6 si4_6 2p
XS4_7 bS4_7 s4_7 vcc veer a4_7 LT1810
RBALS4_7 bS4_7 0 8.93583k
RF4_7 a4_7 s4_7 100k
CFRF4_7 a4_7 s4_7 2p
R4_7_0 na3_0 s4_7 750k
R4_7_1 a3_1 s4_7 127k
R4_7_2 na3_2 s4_7 301k
R4_7_3 na3_3 s4_7 86.6k
R4_7_4 a3_4 s4_7 165k
R4_7_5 a3_5 s4_7 267k
R4_7_6 a3_6 s4_7 267k
R4_7_7 na3_7 s4_7 887k
R4_7_8 a3_8 s4_7 1.47Meg
R4_7_9 a3_9 s4_7 226k
R4_7_10 a3_10 s4_7 95.3k
R4_7_14 a3_14 s4_7 750k
R4_7_15 na3_15 s4_7 243k
R4_7_16 a3_16 s4_7 205k
R4_7_17 a3_17 s4_7 80.6k
R4_7_18 na3_18 s4_7 1.62Meg
R4_7_19 na3_19 s4_7 2.74Meg
R4_7_20 a3_20 s4_7 169k
R4_7_21 na3_21 s4_7 205k
R4_7_22 a3_22 s4_7 392k
R4_7_23 na3_23 s4_7 95.3k
XI4_7 bI4_7 si4_7 vcc vee na4_7 LT1810
RBALI4_7 bI4_7 0 50k
RIA4_7 a4_7 si4_7 100k
RIF4_7 na4_7 si4_7 100k
CFRIF4_7 na4_7 si4_7 2p
XS4_8 bS4_8 s4_8 vcc veer a4_8 LT1810
RBALS4_8 bS4_8 0 7.39764k
RF4_8 a4_8 s4_8 100k
CFRF4_8 a4_8 s4_8 2p
R4_8_0 a3_0 s4_8 137k
R4_8_1 a3_1 s4_8 255k
R4_8_2 a3_2 s4_8 105k
R4_8_3 na3_3 s4_8 118k
R4_8_4 na3_4 s4_8 332k
R4_8_5 na3_5 s4_8 280k
R4_8_6 na3_6 s4_8 215k
R4_8_7 na3_7 s4_8 64.9k
R4_8_8 na3_8 s4_8 383k
R4_8_9 na3_9 s4_8 464k
R4_8_10 a3_10 s4_8 100k
R4_8_12 na3_12 s4_8 523k
R4_8_13 na3_13 s4_8 150k
R4_8_14 a3_14 s4_8 210k
R4_8_15 na3_15 s4_8 442k
R4_8_16 a3_16 s4_8 102k
R4_8_17 a3_17 s4_8 100k
R4_8_18 na3_18 s4_8 453k
R4_8_19 na3_19 s4_8 549k
R4_8_20 na3_20 s4_8 324k
R4_8_21 na3_21 s4_8 309k
R4_8_22 a3_22 s4_8 442k
R4_8_23 na3_23 s4_8 221k
RB4_8 bn s4_8 499k
XI4_8 bI4_8 si4_8 vcc vee na4_8 LT1810
RBALI4_8 bI4_8 0 50k
RIA4_8 a4_8 si4_8 100k
RIF4_8 na4_8 si4_8 100k
CFRIF4_8 na4_8 si4_8 2p
XS4_9 bS4_9 s4_9 vcc veer a4_9 LT1810
RBALS4_9 bS4_9 0 11.4158k
RF4_9 a4_9 s4_9 100k
CFRF4_9 a4_9 s4_9 2p
R4_9_0 a3_0 s4_9 150k
R4_9_1 na3_1 s4_9 332k
R4_9_2 a3_2 s4_9 523k
R4_9_3 na3_3 s4_9 133k
R4_9_4 a3_4 s4_9 255k
R4_9_5 a3_5 s4_9 316k
R4_9_6 a3_6 s4_9 127k
R4_9_7 na3_7 s4_9 2.8Meg
R4_9_8 a3_8 s4_9 1.4Meg
R4_9_9 a3_9 s4_9 154k
R4_9_10 na3_10 s4_9 931k
R4_9_11 a3_11 s4_9 523k
R4_9_12 na3_12 s4_9 453k
R4_9_14 na3_14 s4_9 732k
R4_9_15 na3_15 s4_9 178k
R4_9_16 na3_16 s4_9 523k
R4_9_17 na3_17 s4_9 255k
R4_9_18 na3_18 s4_9 130k
R4_9_19 a3_19 s4_9 187k
R4_9_22 a3_22 s4_9 422k
R4_9_23 na3_23 s4_9 681k
RB4_9 bn s4_9 931k
XI4_9 bI4_9 si4_9 vcc vee na4_9 LT1810
RBALI4_9 bI4_9 0 50k
RIA4_9 a4_9 si4_9 100k
RIF4_9 na4_9 si4_9 100k
CFRIF4_9 na4_9 si4_9 2p
XS4_10 bS4_10 s4_10 vcc veer a4_10 LT1810
RBALS4_10 bS4_10 0 16.7168k
RF4_10 a4_10 s4_10 100k
CFRF4_10 a4_10 s4_10 2p
R4_10_0 na3_0 s4_10 576k
R4_10_1 na3_1 s4_10 357k
R4_10_2 a3_2 s4_10 576k
R4_10_3 a3_3 s4_10 374k
R4_10_4 a3_4 s4_10 715k
R4_10_5 a3_5 s4_10 909k
R4_10_6 a3_6 s4_10 261k
R4_10_7 a3_7 s4_10 845k
R4_10_8 a3_8 s4_10 604k
R4_10_9 na3_9 s4_10 475k
R4_10_10 a3_10 s4_10 887k
R4_10_11 a3_11 s4_10 845k
R4_10_13 a3_13 s4_10 261k
R4_10_15 a3_15 s4_10 243k
R4_10_16 a3_16 s4_10 536k
R4_10_17 na3_17 s4_10 187k
R4_10_18 na3_18 s4_10 887k
R4_10_20 a3_20 s4_10 2.32Meg
R4_10_21 a3_21 s4_10 226k
R4_10_22 a3_22 s4_10 1.1Meg
R4_10_23 a3_23 s4_10 191k
XI4_10 bI4_10 si4_10 vcc vee na4_10 LT1810
RBALI4_10 bI4_10 0 50k
RIA4_10 a4_10 si4_10 100k
RIF4_10 na4_10 si4_10 100k
CFRIF4_10 na4_10 si4_10 2p
XS4_11 bS4_11 s4_11 vcc veer a4_11 LT1810
RBALS4_11 bS4_11 0 10.5063k
RF4_11 a4_11 s4_11 100k
CFRF4_11 a4_11 s4_11 2p
R4_11_0 na3_0 s4_11 137k
R4_11_1 na3_1 s4_11 412k
R4_11_2 a3_2 s4_11 3.09Meg
R4_11_3 a3_3 s4_11 137k
R4_11_4 na3_4 s4_11 590k
R4_11_5 na3_5 s4_11 562k
R4_11_6 a3_6 s4_11 887k
R4_11_7 na3_7 s4_11 332k
R4_11_8 a3_8 s4_11 1.78Meg
R4_11_9 na3_9 s4_11 402k
R4_11_10 na3_10 s4_11 93.1k
R4_11_11 a3_11 s4_11 806k
R4_11_12 na3_12 s4_11 274k
R4_11_13 a3_13 s4_11 1.02Meg
R4_11_14 na3_14 s4_11 309k
R4_11_15 a3_15 s4_11 324k
R4_11_16 na3_16 s4_11 162k
R4_11_17 na3_17 s4_11 115k
R4_11_18 na3_18 s4_11 604k
R4_11_19 na3_19 s4_11 348k
R4_11_20 na3_20 s4_11 249k
R4_11_21 a3_21 s4_11 309k
R4_11_22 na3_22 s4_11 768k
R4_11_23 a3_23 s4_11 182k
RB4_11 bn s4_11 1.27Meg
XI4_11 bI4_11 si4_11 vcc vee na4_11 LT1810
RBALI4_11 bI4_11 0 50k
RIA4_11 a4_11 si4_11 100k
RIF4_11 na4_11 si4_11 100k
CFRIF4_11 na4_11 si4_11 2p
XS4_12 bS4_12 s4_12 vcc veer a4_12 LT1810
RBALS4_12 bS4_12 0 8.82933k
RF4_12 a4_12 s4_12 100k
CFRF4_12 a4_12 s4_12 2p
R4_12_0 na3_0 s4_12 210k
R4_12_1 a3_1 s4_12 301k
R4_12_2 a3_2 s4_12 261k
R4_12_3 na3_3 s4_12 806k
R4_12_4 na3_4 s4_12 88.7k
R4_12_5 na3_5 s4_12 287k
R4_12_6 a3_6 s4_12 681k
R4_12_7 na3_7 s4_12 127k
R4_12_8 a3_8 s4_12 442k
R4_12_9 na3_9 s4_12 2.49Meg
R4_12_10 na3_10 s4_12 511k
R4_12_11 na3_11 s4_12 1.43Meg
R4_12_12 na3_12 s4_12 261k
R4_12_13 a3_13 s4_12 402k
R4_12_14 a3_14 s4_12 82.5k
R4_12_15 na3_15 s4_12 665k
R4_12_16 a3_16 s4_12 232k
R4_12_17 a3_17 s4_12 196k
R4_12_18 a3_18 s4_12 402k
R4_12_19 a3_19 s4_12 90.9k
R4_12_20 a3_20 s4_12 147k
R4_12_21 na3_21 s4_12 210k
R4_12_22 a3_22 s4_12 1.05Meg
R4_12_23 na3_23 s4_12 909k
RB4_12 bn s4_12 237k
XI4_12 bI4_12 si4_12 vcc vee na4_12 LT1810
RBALI4_12 bI4_12 0 50k
RIA4_12 a4_12 si4_12 100k
RIF4_12 na4_12 si4_12 100k
CFRIF4_12 na4_12 si4_12 2p
XS4_13 bS4_13 s4_13 vcc veer a4_13 LT1810
RBALS4_13 bS4_13 0 10.2682k
RF4_13 a4_13 s4_13 100k
CFRF4_13 a4_13 s4_13 2p
R4_13_0 a3_0 s4_13 536k
R4_13_1 na3_1 s4_13 169k
R4_13_2 na3_2 s4_13 226k
R4_13_3 a3_3 s4_13 205k
R4_13_4 na3_4 s4_13 237k
R4_13_6 a3_6 s4_13 402k
R4_13_7 na3_7 s4_13 301k
R4_13_8 na3_8 s4_13 178k
R4_13_9 na3_9 s4_13 287k
R4_13_10 a3_10 s4_13 1.54Meg
R4_13_11 na3_11 s4_13 249k
R4_13_12 a3_12 s4_13 243k
R4_13_13 a3_13 s4_13 140k
R4_13_14 a3_14 s4_13 383k
R4_13_15 a3_15 s4_13 249k
R4_13_16 a3_16 s4_13 806k
R4_13_17 na3_17 s4_13 210k
R4_13_18 na3_18 s4_13 3.16Meg
R4_13_20 a3_20 s4_13 127k
R4_13_21 na3_21 s4_13 1.18Meg
R4_13_22 a3_22 s4_13 95.3k
R4_13_23 na3_23 s4_13 324k
XI4_13 bI4_13 si4_13 vcc vee na4_13 LT1810
RBALI4_13 bI4_13 0 50k
RIA4_13 a4_13 si4_13 100k
RIF4_13 na4_13 si4_13 100k
CFRIF4_13 na4_13 si4_13 2p
XS4_14 bS4_14 s4_14 vcc veer a4_14 LT1810
RBALS4_14 bS4_14 0 10.2951k
RF4_14 a4_14 s4_14 100k
CFRF4_14 a4_14 s4_14 2p
R4_14_0 a3_0 s4_14 866k
R4_14_2 na3_2 s4_14 221k
R4_14_3 a3_3 s4_14 191k
R4_14_4 na3_4 s4_14 2.37Meg
R4_14_5 a3_5 s4_14 402k
R4_14_6 a3_6 s4_14 73.2k
R4_14_7 a3_7 s4_14 681k
R4_14_8 a3_8 s4_14 562k
R4_14_9 a3_9 s4_14 143k
R4_14_10 a3_10 s4_14 226k
R4_14_11 na3_11 s4_14 953k
R4_14_12 na3_12 s4_14 845k
R4_14_13 na3_13 s4_14 365k
R4_14_14 a3_14 s4_14 107k
R4_14_15 na3_15 s4_14 316k
R4_14_16 na3_16 s4_14 1.5Meg
R4_14_17 a3_17 s4_14 143k
R4_14_18 na3_18 s4_14 422k
R4_14_19 a3_19 s4_14 422k
R4_14_20 na3_20 s4_14 422k
R4_14_21 na3_21 s4_14 365k
R4_14_22 a3_22 s4_14 249k
R4_14_23 na3_23 s4_14 487k
RB4_14 bn s4_14 255k
XI4_14 bI4_14 si4_14 vcc vee na4_14 LT1810
RBALI4_14 bI4_14 0 50k
RIA4_14 a4_14 si4_14 100k
RIF4_14 na4_14 si4_14 100k
CFRIF4_14 na4_14 si4_14 2p
XS4_15 bS4_15 s4_15 vcc veer a4_15 LT1810
RBALS4_15 bS4_15 0 9.05383k
RF4_15 a4_15 s4_15 100k
CFRF4_15 a4_15 s4_15 2p
R4_15_0 a3_0 s4_15 619k
R4_15_1 na3_1 s4_15 549k
R4_15_2 na3_2 s4_15 196k
R4_15_3 a3_3 s4_15 562k
R4_15_4 a3_4 s4_15 1.15Meg
R4_15_6 na3_6 s4_15 100k
R4_15_7 na3_7 s4_15 976k
R4_15_9 na3_9 s4_15 232k
R4_15_10 na3_10 s4_15 102k
R4_15_11 a3_11 s4_15 357k
R4_15_12 na3_12 s4_15 232k
R4_15_13 na3_13 s4_15 750k
R4_15_14 a3_14 s4_15 374k
R4_15_15 na3_15 s4_15 340k
R4_15_16 a3_16 s4_15 118k
R4_15_17 na3_17 s4_15 105k
R4_15_18 a3_18 s4_15 232k
R4_15_19 na3_19 s4_15 324k
R4_15_20 na3_20 s4_15 133k
R4_15_21 a3_21 s4_15 536k
R4_15_22 na3_22 s4_15 88.7k
R4_15_23 na3_23 s4_15 365k
RB4_15 bp s4_15 787k
XI4_15 bI4_15 si4_15 vcc vee na4_15 LT1810
RBALI4_15 bI4_15 0 50k
RIA4_15 a4_15 si4_15 100k
RIF4_15 na4_15 si4_15 100k
CFRIF4_15 na4_15 si4_15 2p
* ---- stage 5: 16 -> 10 (output, linear)
XS5_0 bS5_0 s5_0 vcc vee z0 LT1810
RBALS5_0 bS5_0 0 10.8287k
RF5_0 z0 s5_0 100k
CFRF5_0 z0 s5_0 2p
R5_0_0 a4_0 s5_0 102k
R5_0_1 na4_1 s5_0 130k
R5_0_2 na4_2 s5_0 1.02Meg
R5_0_3 na4_3 s5_0 215k
R5_0_4 a4_4 s5_0 562k
R5_0_5 na4_5 s5_0 340k
R5_0_6 na4_6 s5_0 681k
R5_0_7 a4_7 s5_0 909k
R5_0_8 a4_8 s5_0 255k
R5_0_9 a4_9 s5_0 133k
R5_0_10 na4_10 s5_0 249k
R5_0_11 a4_11 s5_0 63.4k
R5_0_12 a4_12 s5_0 66.5k
R5_0_15 na4_15 s5_0 412k
RB5_0 bp s5_0 309k
XS5_1 bS5_1 s5_1 vcc vee z1 LT1810
RBALS5_1 bS5_1 0 11.991k
RF5_1 z1 s5_1 100k
CFRF5_1 z1 s5_1 2p
R5_1_0 a4_0 s5_1 137k
R5_1_1 na4_1 s5_1 1.18Meg
R5_1_2 na4_2 s5_1 140k
R5_1_3 a4_3 s5_1 205k
R5_1_4 a4_4 s5_1 287k
R5_1_5 a4_5 s5_1 392k
R5_1_6 a4_6 s5_1 316k
R5_1_7 a4_7 s5_1 249k
R5_1_8 a4_8 s5_1 143k
R5_1_9 na4_9 s5_1 243k
R5_1_10 a4_10 s5_1 5.76Meg
R5_1_11 na4_11 s5_1 280k
R5_1_12 a4_12 s5_1 187k
R5_1_13 a4_13 s5_1 267k
R5_1_14 na4_14 s5_1 140k
R5_1_15 na4_15 s5_1 127k
RB5_1 bn s5_1 953k
XS5_2 bS5_2 s5_2 vcc vee z2 LT1810
RBALS5_2 bS5_2 0 10.5419k
RF5_2 z2 s5_2 100k
CFRF5_2 z2 s5_2 2p
R5_2_0 a4_0 s5_2 124k
R5_2_1 a4_1 s5_2 140k
R5_2_2 a4_2 s5_2 115k
R5_2_3 na4_3 s5_2 84.5k
R5_2_4 na4_4 s5_2 301k
R5_2_5 na4_5 s5_2 453k
R5_2_6 a4_6 s5_2 210k
R5_2_7 a4_7 s5_2 110k
R5_2_8 a4_8 s5_2 768k
R5_2_9 a4_9 s5_2 511k
R5_2_10 a4_10 s5_2 374k
R5_2_11 na4_11 s5_2 1.1Meg
R5_2_12 na4_12 s5_2 267k
R5_2_13 na4_13 s5_2 124k
R5_2_14 na4_14 s5_2 402k
R5_2_15 a4_15 s5_2 162k
RB5_2 bn s5_2 412k
XS5_3 bS5_3 s5_3 vcc vee z3 LT1810
RBALS5_3 bS5_3 0 12.6118k
RF5_3 z3 s5_3 100k
CFRF5_3 z3 s5_3 2p
R5_3_0 na4_0 s5_3 174k
R5_3_2 na4_2 s5_3 340k
R5_3_3 na4_3 s5_3 365k
R5_3_4 a4_4 s5_3 82.5k
R5_3_6 na4_6 s5_3 845k
R5_3_7 a4_7 s5_3 90.9k
R5_3_8 na4_8 s5_3 412k
R5_3_9 na4_9 s5_3 174k
R5_3_10 a4_10 s5_3 523k
R5_3_11 a4_11 s5_3 232k
R5_3_12 a4_12 s5_3 133k
R5_3_13 a4_13 s5_3 158k
R5_3_14 a4_14 s5_3 221k
RB5_3 bn s5_3 1.27Meg
XS5_4 bS5_4 s5_4 vcc vee z4 LT1810
RBALS5_4 bS5_4 0 11.3148k
RF5_4 z4 s5_4 100k
CFRF5_4 z4 s5_4 2p
R5_4_0 a4_0 s5_4 549k
R5_4_1 a4_1 s5_4 249k
R5_4_2 a4_2 s5_4 100k
R5_4_3 a4_3 s5_4 392k
R5_4_4 na4_4 s5_4 309k
R5_4_5 a4_5 s5_4 169k
R5_4_6 na4_6 s5_4 205k
R5_4_7 a4_7 s5_4 86.6k
R5_4_8 na4_8 s5_4 140k
R5_4_9 a4_9 s5_4 845k
R5_4_10 na4_10 s5_4 432k
R5_4_11 a4_11 s5_4 210k
R5_4_12 a4_12 s5_4 137k
R5_4_13 na4_13 s5_4 845k
R5_4_14 a4_14 s5_4 348k
R5_4_15 na4_15 s5_4 196k
RB5_4 bn s5_4 392k
XS5_5 bS5_5 s5_5 vcc vee z5 LT1810
RBALS5_5 bS5_5 0 14.5406k
RF5_5 z5 s5_5 100k
CFRF5_5 z5 s5_5 2p
R5_5_0 a4_0 s5_5 154k
R5_5_1 a4_1 s5_5 182k
R5_5_2 na4_2 s5_5 715k
R5_5_3 na4_3 s5_5 604k
R5_5_4 a4_4 s5_5 68.1k
R5_5_5 na4_5 s5_5 1.37Meg
R5_5_6 na4_6 s5_5 374k
R5_5_7 na4_7 s5_5 232k
R5_5_8 na4_8 s5_5 1.43Meg
R5_5_9 a4_9 s5_5 332k
R5_5_11 a4_11 s5_5 453k
R5_5_12 na4_12 s5_5 102k
R5_5_13 na4_13 s5_5 210k
R5_5_14 na4_14 s5_5 1.18Meg
XS5_6 bS5_6 s5_6 vcc vee z6 LT1810
RBALS5_6 bS5_6 0 10.009k
RF5_6 z6 s5_6 100k
CFRF5_6 z6 s5_6 2p
R5_6_0 a4_0 s5_6 147k
R5_6_1 a4_1 s5_6 143k
R5_6_2 a4_2 s5_6 487k
R5_6_3 a4_3 s5_6 221k
R5_6_4 a4_4 s5_6 301k
R5_6_5 na4_5 s5_6 174k
R5_6_6 a4_6 s5_6 154k
R5_6_7 na4_7 s5_6 121k
R5_6_8 na4_8 s5_6 261k
R5_6_9 a4_9 s5_6 232k
R5_6_10 na4_10 s5_6 249k
R5_6_11 a4_11 s5_6 115k
R5_6_12 a4_12 s5_6 80.6k
R5_6_13 a4_13 s5_6 196k
R5_6_14 na4_14 s5_6 221k
R5_6_15 na4_15 s5_6 464k
RB5_6 bp s5_6 1.5Meg
XS5_7 bS5_7 s5_7 vcc vee z7 LT1810
RBALS5_7 bS5_7 0 11.3977k
RF5_7 z7 s5_7 100k
CFRF5_7 z7 s5_7 2p
R5_7_0 na4_0 s5_7 200k
R5_7_1 na4_1 s5_7 274k
R5_7_2 a4_2 s5_7 80.6k
R5_7_3 na4_3 s5_7 255k
R5_7_4 a4_4 s5_7 294k
R5_7_5 a4_5 s5_7 121k
R5_7_6 na4_6 s5_7 174k
R5_7_7 a4_7 s5_7 118k
R5_7_8 a4_8 s5_7 124k
R5_7_9 a4_9 s5_7 133k
R5_7_10 na4_10 s5_7 23.2Meg
R5_7_11 na4_11 s5_7 392k
R5_7_12 na4_12 s5_7 340k
R5_7_13 na4_13 s5_7 402k
R5_7_14 a4_14 s5_7 825k
R5_7_15 na4_15 s5_7 487k
XS5_8 bS5_8 s5_8 vcc vee z8 LT1810
RBALS5_8 bS5_8 0 11.2419k
RF5_8 z8 s5_8 100k
CFRF5_8 z8 s5_8 2p
R5_8_1 a4_1 s5_8 178k
R5_8_2 a4_2 s5_8 174k
R5_8_3 na4_3 s5_8 169k
R5_8_4 a4_4 s5_8 698k
R5_8_5 a4_5 s5_8 118k
R5_8_6 na4_6 s5_8 147k
R5_8_7 na4_7 s5_8 221k
R5_8_8 a4_8 s5_8 196k
R5_8_9 na4_9 s5_8 249k
R5_8_11 a4_11 s5_8 150k
R5_8_12 a4_12 s5_8 100k
R5_8_13 a4_13 s5_8 130k
R5_8_14 na4_14 s5_8 237k
R5_8_15 a4_15 s5_8 365k
XS5_9 bS5_9 s5_9 vcc vee z9 LT1810
RBALS5_9 bS5_9 0 11.8243k
RF5_9 z9 s5_9 100k
CFRF5_9 z9 s5_9 2p
R5_9_0 a4_0 s5_9 698k
R5_9_1 na4_1 s5_9 100k
R5_9_2 a4_2 s5_9 169k
R5_9_3 a4_3 s5_9 243k
R5_9_4 a4_4 s5_9 261k
R5_9_5 a4_5 s5_9 1.05Meg
R5_9_7 a4_7 s5_9 267k
R5_9_8 na4_8 s5_9 287k
R5_9_9 na4_9 s5_9 442k
R5_9_10 a4_10 s5_9 226k
R5_9_11 a4_11 s5_9 100k
R5_9_12 na4_12 s5_9 221k
R5_9_13 a4_13 s5_9 237k
R5_9_14 na4_14 s5_9 147k
R5_9_15 a4_15 s5_9 143k
RB5_9 bn s5_9 536k
* ---- comparators: one op-amp per digit, fires above VTH
XC0 z0 vth vcc veer out0 LT1810
RL0 out0 0 100k
XC1 z1 vth vcc veer out1 LT1810
RL1 out1 0 100k
XC2 z2 vth vcc veer out2 LT1810
RL2 out2 0 100k
XC3 z3 vth vcc veer out3 LT1810
RL3 out3 0 100k
XC4 z4 vth vcc veer out4 LT1810
RL4 out4 0 100k
XC5 z5 vth vcc veer out5 LT1810
RL5 out5 0 100k
XC6 z6 vth vcc veer out6 LT1810
RL6 out6 0 100k
XC7 z7 vth vcc veer out7 LT1810
RL7 out7 0 100k
XC8 z8 vth vcc veer out8 LT1810
RL8 out8 0 100k
XC9 z9 vth vcc veer out9 LT1810
RL9 out9 0 100k
.save V(z0) V(z1) V(z2) V(z3) V(z4) V(z5) V(z6) V(z7) V(z8) V(z9) V(out0) V(out1) V(out2) V(out3) V(out4) V(out5) V(out6) V(out7) V(out8) V(out9)
.options method=Gear
.options trtol=7
.options reltol=2e-3
.options vntol=1e-5
.options abstol=1e-9
.options itl4=100
.options gmin=1e-10
.meas TRAN z_v0_d0 FIND V(z0) AT=11u
.meas TRAN out_v0_d0 FIND V(out0) AT=11u
.meas TRAN z_v0_d1 FIND V(z1) AT=11u
.meas TRAN out_v0_d1 FIND V(out1) AT=11u
.meas TRAN z_v0_d2 FIND V(z2) AT=11u
.meas TRAN out_v0_d2 FIND V(out2) AT=11u
.meas TRAN z_v0_d3 FIND V(z3) AT=11u
.meas TRAN out_v0_d3 FIND V(out3) AT=11u
.meas TRAN z_v0_d4 FIND V(z4) AT=11u
.meas TRAN out_v0_d4 FIND V(out4) AT=11u
.meas TRAN z_v0_d5 FIND V(z5) AT=11u
.meas TRAN out_v0_d5 FIND V(out5) AT=11u
.meas TRAN z_v0_d6 FIND V(z6) AT=11u
.meas TRAN out_v0_d6 FIND V(out6) AT=11u
.meas TRAN z_v0_d7 FIND V(z7) AT=11u
.meas TRAN out_v0_d7 FIND V(out7) AT=11u
.meas TRAN z_v0_d8 FIND V(z8) AT=11u
.meas TRAN out_v0_d8 FIND V(out8) AT=11u
.meas TRAN z_v0_d9 FIND V(z9) AT=11u
.meas TRAN out_v0_d9 FIND V(out9) AT=11u
.meas TRAN z_v1_d0 FIND V(z0) AT=26u
.meas TRAN out_v1_d0 FIND V(out0) AT=26u
.meas TRAN z_v1_d1 FIND V(z1) AT=26u
.meas TRAN out_v1_d1 FIND V(out1) AT=26u
.meas TRAN z_v1_d2 FIND V(z2) AT=26u
.meas TRAN out_v1_d2 FIND V(out2) AT=26u
.meas TRAN z_v1_d3 FIND V(z3) AT=26u
.meas TRAN out_v1_d3 FIND V(out3) AT=26u
.meas TRAN z_v1_d4 FIND V(z4) AT=26u
.meas TRAN out_v1_d4 FIND V(out4) AT=26u
.meas TRAN z_v1_d5 FIND V(z5) AT=26u
.meas TRAN out_v1_d5 FIND V(out5) AT=26u
.meas TRAN z_v1_d6 FIND V(z6) AT=26u
.meas TRAN out_v1_d6 FIND V(out6) AT=26u
.meas TRAN z_v1_d7 FIND V(z7) AT=26u
.meas TRAN out_v1_d7 FIND V(out7) AT=26u
.meas TRAN z_v1_d8 FIND V(z8) AT=26u
.meas TRAN out_v1_d8 FIND V(out8) AT=26u
.meas TRAN z_v1_d9 FIND V(z9) AT=26u
.meas TRAN out_v1_d9 FIND V(out9) AT=26u
.meas TRAN z_v2_d0 FIND V(z0) AT=41u
.meas TRAN out_v2_d0 FIND V(out0) AT=41u
.meas TRAN z_v2_d1 FIND V(z1) AT=41u
.meas TRAN out_v2_d1 FIND V(out1) AT=41u
.meas TRAN z_v2_d2 FIND V(z2) AT=41u
.meas TRAN out_v2_d2 FIND V(out2) AT=41u
.meas TRAN z_v2_d3 FIND V(z3) AT=41u
.meas TRAN out_v2_d3 FIND V(out3) AT=41u
.meas TRAN z_v2_d4 FIND V(z4) AT=41u
.meas TRAN out_v2_d4 FIND V(out4) AT=41u
.meas TRAN z_v2_d5 FIND V(z5) AT=41u
.meas TRAN out_v2_d5 FIND V(out5) AT=41u
.meas TRAN z_v2_d6 FIND V(z6) AT=41u
.meas TRAN out_v2_d6 FIND V(out6) AT=41u
.meas TRAN z_v2_d7 FIND V(z7) AT=41u
.meas TRAN out_v2_d7 FIND V(out7) AT=41u
.meas TRAN z_v2_d8 FIND V(z8) AT=41u
.meas TRAN out_v2_d8 FIND V(out8) AT=41u
.meas TRAN z_v2_d9 FIND V(z9) AT=41u
.meas TRAN out_v2_d9 FIND V(out9) AT=41u
.meas TRAN z_v3_d0 FIND V(z0) AT=56u
.meas TRAN out_v3_d0 FIND V(out0) AT=56u
.meas TRAN z_v3_d1 FIND V(z1) AT=56u
.meas TRAN out_v3_d1 FIND V(out1) AT=56u
.meas TRAN z_v3_d2 FIND V(z2) AT=56u
.meas TRAN out_v3_d2 FIND V(out2) AT=56u
.meas TRAN z_v3_d3 FIND V(z3) AT=56u
.meas TRAN out_v3_d3 FIND V(out3) AT=56u
.meas TRAN z_v3_d4 FIND V(z4) AT=56u
.meas TRAN out_v3_d4 FIND V(out4) AT=56u
.meas TRAN z_v3_d5 FIND V(z5) AT=56u
.meas TRAN out_v3_d5 FIND V(out5) AT=56u
.meas TRAN z_v3_d6 FIND V(z6) AT=56u
.meas TRAN out_v3_d6 FIND V(out6) AT=56u
.meas TRAN z_v3_d7 FIND V(z7) AT=56u
.meas TRAN out_v3_d7 FIND V(out7) AT=56u
.meas TRAN z_v3_d8 FIND V(z8) AT=56u
.meas TRAN out_v3_d8 FIND V(out8) AT=56u
.meas TRAN z_v3_d9 FIND V(z9) AT=56u
.meas TRAN out_v3_d9 FIND V(out9) AT=56u
.meas TRAN z_v4_d0 FIND V(z0) AT=71u
.meas TRAN out_v4_d0 FIND V(out0) AT=71u
.meas TRAN z_v4_d1 FIND V(z1) AT=71u
.meas TRAN out_v4_d1 FIND V(out1) AT=71u
.meas TRAN z_v4_d2 FIND V(z2) AT=71u
.meas TRAN out_v4_d2 FIND V(out2) AT=71u
.meas TRAN z_v4_d3 FIND V(z3) AT=71u
.meas TRAN out_v4_d3 FIND V(out3) AT=71u
.meas TRAN z_v4_d4 FIND V(z4) AT=71u
.meas TRAN out_v4_d4 FIND V(out4) AT=71u
.meas TRAN z_v4_d5 FIND V(z5) AT=71u
.meas TRAN out_v4_d5 FIND V(out5) AT=71u
.meas TRAN z_v4_d6 FIND V(z6) AT=71u
.meas TRAN out_v4_d6 FIND V(out6) AT=71u
.meas TRAN z_v4_d7 FIND V(z7) AT=71u
.meas TRAN out_v4_d7 FIND V(out7) AT=71u
.meas TRAN z_v4_d8 FIND V(z8) AT=71u
.meas TRAN out_v4_d8 FIND V(out8) AT=71u
.meas TRAN z_v4_d9 FIND V(z9) AT=71u
.meas TRAN out_v4_d9 FIND V(out9) AT=71u
.meas TRAN z_v5_d0 FIND V(z0) AT=86u
.meas TRAN out_v5_d0 FIND V(out0) AT=86u
.meas TRAN z_v5_d1 FIND V(z1) AT=86u
.meas TRAN out_v5_d1 FIND V(out1) AT=86u
.meas TRAN z_v5_d2 FIND V(z2) AT=86u
.meas TRAN out_v5_d2 FIND V(out2) AT=86u
.meas TRAN z_v5_d3 FIND V(z3) AT=86u
.meas TRAN out_v5_d3 FIND V(out3) AT=86u
.meas TRAN z_v5_d4 FIND V(z4) AT=86u
.meas TRAN out_v5_d4 FIND V(out4) AT=86u
.meas TRAN z_v5_d5 FIND V(z5) AT=86u
.meas TRAN out_v5_d5 FIND V(out5) AT=86u
.meas TRAN z_v5_d6 FIND V(z6) AT=86u
.meas TRAN out_v5_d6 FIND V(out6) AT=86u
.meas TRAN z_v5_d7 FIND V(z7) AT=86u
.meas TRAN out_v5_d7 FIND V(out7) AT=86u
.meas TRAN z_v5_d8 FIND V(z8) AT=86u
.meas TRAN out_v5_d8 FIND V(out8) AT=86u
.meas TRAN z_v5_d9 FIND V(z9) AT=86u
.meas TRAN out_v5_d9 FIND V(out9) AT=86u
.tran 0 90u 0 2u startup
.end
