* Practical inverting op-amp integrator
.include ../../lib/claw_opamps.lib
VIN in 0 PULSE(-0.1 0.1 0 10u 10u 1m 2m)
VCC vcc 0 5
VEE vee 0 -5
RIN in sum 100k
RLEAK sum out 1Meg
CF sum out 10n
XU1 0 sum vcc vee out CLAW_IDEAL_OPAMP
RL out 0 10k
.tran 0 10m 0 2u
.meas TRAN vout_max MAX V(out) FROM=4m TO=10m
.meas TRAN vout_min MIN V(out) FROM=4m TO=10m
.meas TRAN vout_avg AVG V(out) FROM=4m TO=10m
.end
